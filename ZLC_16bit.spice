* NGSPICE file created from ZLC_16bit.ext - technology: sky130B

.subckt sky130_fd_sc_hd__inv_1 A VGND VNB VPB VPWR Y
X0 Y A VGND VNB sky130_fd_pr__nfet_01v8 ad=0.169 pd=1.82 as=0.169 ps=1.82 w=0.65 l=0.15
X1 Y A VPWR VPB sky130_fd_pr__pfet_01v8_hvt ad=0.26 pd=2.52 as=0.26 ps=2.52 w=1 l=0.15
C0 VGND VPB 0.01319f
C1 VGND A 0.04768f
C2 VGND Y 0.09986f
C3 VPWR VPB 0.06649f
C4 VPWR A 0.04571f
C5 VPWR Y 0.12759f
C6 A VPB 0.04506f
C7 VPB Y 0.01774f
C8 VPWR VGND 0.03401f
C9 A Y 0.0476f
C10 VGND VNB 0.24421f
C11 Y VNB 0.0961f
C12 VPWR VNB 0.20582f
C13 A VNB 0.13301f
C14 VPB VNB 0.33898f
.ends

.subckt sky130_fd_sc_hd__mux4_1 A0 A1 A2 A3 S0 S1 VGND VNB VPB VPWR X a_1290_413#
+ a_757_363# a_1478_413# a_277_47# a_750_97# a_27_413# a_923_363# a_193_47# a_834_97#
+ a_247_21# a_668_97# a_193_413# a_27_47#
X0 a_277_47# a_247_21# a_27_413# VPB sky130_fd_pr__pfet_01v8_hvt ad=0.0567 pd=0.69 as=0.1092 ps=1.36 w=0.42 l=0.15
X1 VGND S0 a_247_21# VNB sky130_fd_pr__nfet_01v8 ad=0.1092 pd=1.36 as=0.1092 ps=1.36 w=0.42 l=0.15
X2 a_834_97# a_247_21# a_750_97# VNB sky130_fd_pr__nfet_01v8 ad=0.10795 pd=1.36 as=0.0567 ps=0.69 w=0.42 l=0.15
X3 VGND A3 a_668_97# VNB sky130_fd_pr__nfet_01v8 ad=0.0567 pd=0.69 as=0.1079 ps=1.36 w=0.42 l=0.15
X4 a_1290_413# S1 VPWR VPB sky130_fd_pr__pfet_01v8_hvt ad=0.1092 pd=1.36 as=0.1092 ps=1.36 w=0.42 l=0.15
X5 a_834_97# A2 VGND VNB sky130_fd_pr__nfet_01v8 ad=0.1092 pd=1.36 as=0.0567 ps=0.69 w=0.42 l=0.15
X6 a_750_97# S0 a_757_363# VPB sky130_fd_pr__pfet_01v8_hvt ad=0.0567 pd=0.69 as=0.1079 ps=1.36 w=0.42 l=0.15
X7 a_27_47# S0 a_277_47# VNB sky130_fd_pr__nfet_01v8 ad=0.1092 pd=1.36 as=0.08522 ps=0.925 w=0.42 l=0.15
X8 X a_1478_413# VGND VNB sky130_fd_pr__nfet_01v8 ad=0.169 pd=1.82 as=0.169 ps=1.82 w=0.65 l=0.15
X9 VPWR A1 a_27_413# VPB sky130_fd_pr__pfet_01v8_hvt ad=0.0567 pd=0.69 as=0.1092 ps=1.36 w=0.42 l=0.15
X10 VPWR S0 a_247_21# VPB sky130_fd_pr__pfet_01v8_hvt ad=0.1079 pd=1.36 as=0.1083 ps=1.36 w=0.42 l=0.15
X11 X a_1478_413# VPWR VPB sky130_fd_pr__pfet_01v8_hvt ad=0.26 pd=2.52 as=0.26 ps=2.52 w=1 l=0.15
X12 a_193_47# A0 VGND VNB sky130_fd_pr__nfet_01v8 ad=0.0567 pd=0.69 as=0.0567 ps=0.69 w=0.42 l=0.15
X13 a_750_97# a_1290_413# a_1478_413# VPB sky130_fd_pr__pfet_01v8_hvt ad=0.2688 pd=2.12 as=0.09207 ps=0.99 w=0.42 l=0.15
X14 a_1478_413# S1 a_277_47# VPB sky130_fd_pr__pfet_01v8_hvt ad=0.09207 pd=0.99 as=0.1092 ps=1.36 w=0.42 l=0.15
X15 a_1290_413# S1 VGND VNB sky130_fd_pr__nfet_01v8 ad=0.1092 pd=1.36 as=0.1092 ps=1.36 w=0.42 l=0.15
X16 a_277_47# a_247_21# a_193_47# VNB sky130_fd_pr__nfet_01v8 ad=0.08522 pd=0.925 as=0.0567 ps=0.69 w=0.42 l=0.15
X17 a_750_97# S0 a_668_97# VNB sky130_fd_pr__nfet_01v8 ad=0.0567 pd=0.69 as=0.1092 ps=1.36 w=0.42 l=0.15
X18 a_923_363# a_247_21# a_750_97# VPB sky130_fd_pr__pfet_01v8_hvt ad=0.09012 pd=0.995 as=0.0567 ps=0.69 w=0.42 l=0.15
X19 a_757_363# A2 VPWR VPB sky130_fd_pr__pfet_01v8_hvt ad=0.1092 pd=1.36 as=0.0567 ps=0.69 w=0.42 l=0.15
X20 VPWR A3 a_923_363# VPB sky130_fd_pr__pfet_01v8_hvt ad=0.0567 pd=0.69 as=0.09012 ps=0.995 w=0.42 l=0.15
X21 a_277_47# a_1290_413# a_1478_413# VNB sky130_fd_pr__nfet_01v8 ad=0.1092 pd=1.36 as=0.15102 ps=1.285 w=0.42 l=0.15
X22 a_193_413# A0 VPWR VPB sky130_fd_pr__pfet_01v8_hvt ad=0.1092 pd=1.36 as=0.0567 ps=0.69 w=0.42 l=0.15
X23 a_193_413# S0 a_277_47# VPB sky130_fd_pr__pfet_01v8_hvt ad=0.1079 pd=1.36 as=0.0567 ps=0.69 w=0.42 l=0.15
X24 VGND A1 a_27_47# VNB sky130_fd_pr__nfet_01v8 ad=0.0567 pd=0.69 as=0.1092 ps=1.36 w=0.42 l=0.15
X25 a_1478_413# S1 a_750_97# VNB sky130_fd_pr__nfet_01v8 ad=0.15102 pd=1.285 as=0.1092 ps=1.36 w=0.42 l=0.15
C0 a_277_47# a_1478_413# 0.09609f
C1 a_247_21# VPWR 0.15113f
C2 a_193_47# VGND 0.00185f
C3 a_27_47# VPWR 0.00181f
C4 VPB a_1478_413# 0.07799f
C5 S1 VGND 0.04098f
C6 A3 VGND 0.01282f
C7 a_277_47# A2 0.01375f
C8 a_668_97# VGND 0.22385f
C9 a_750_97# VGND 0.05697f
C10 a_834_97# a_923_363# 0
C11 a_757_363# VGND 0
C12 a_750_97# a_193_413# 0
C13 VPB A2 0.07872f
C14 a_923_363# VPWR 0.00316f
C15 a_277_47# X 0
C16 S0 A3 0.00317f
C17 a_247_21# S1 0
C18 a_247_21# A3 0.07395f
C19 a_1290_413# a_1478_413# 0.10639f
C20 A0 VGND 0.01709f
C21 S0 a_668_97# 0.03129f
C22 S0 a_750_97# 0.09449f
C23 A0 a_193_413# 0.00273f
C24 a_27_47# a_193_47# 0.00665f
C25 VPB X 0.01271f
C26 S0 a_757_363# 0.03445f
C27 a_668_97# a_247_21# 0.01904f
C28 a_247_21# a_750_97# 0.12496f
C29 a_27_47# A3 0
C30 a_277_47# A1 0.00101f
C31 a_277_47# VPB 0.04196f
C32 a_757_363# a_247_21# 0.02646f
C33 a_834_97# VPWR 0
C34 a_27_413# VGND 0.0019f
C35 a_27_413# a_193_413# 0.05572f
C36 A2 a_1290_413# 0.00165f
C37 VPB A1 0.0741f
C38 S0 A0 0.00186f
C39 a_247_21# A0 0.07359f
C40 A3 a_923_363# 0
C41 a_1290_413# X 0.00208f
C42 S0 a_27_413# 0
C43 VGND a_1478_413# 0.19192f
C44 a_27_47# A0 0.04595f
C45 a_750_97# a_923_363# 0.003f
C46 a_247_21# a_27_413# 0.0067f
C47 a_277_47# a_1290_413# 0.34635f
C48 a_757_363# a_923_363# 0.00996f
C49 a_27_47# a_27_413# 0.00987f
C50 a_834_97# S1 0.00219f
C51 a_834_97# A3 0.03624f
C52 VPB a_1290_413# 0.14946f
C53 a_193_47# VPWR 0
C54 A2 VGND 0.0136f
C55 S1 VPWR 0.04098f
C56 A3 VPWR 0.012f
C57 a_668_97# a_834_97# 0.05606f
C58 a_750_97# a_834_97# 0.0296f
C59 a_247_21# a_1478_413# 0
C60 a_757_363# a_834_97# 0.01352f
C61 a_668_97# VPWR 0.00181f
C62 a_750_97# VPWR 0.22712f
C63 VGND X 0.06f
C64 a_757_363# VPWR 0.24916f
C65 a_277_47# VGND 0.41249f
C66 a_277_47# a_193_413# 0.05978f
C67 a_247_21# A2 0.00145f
C68 A0 VPWR 0.01747f
C69 VGND A1 0.01705f
C70 VPB VGND 0.01524f
C71 a_193_413# A1 0
C72 VPB a_193_413# 0.02107f
C73 S1 A3 0
C74 a_247_21# X 0
C75 S0 a_277_47# 0.03533f
C76 a_27_413# VPWR 0.08457f
C77 a_277_47# a_247_21# 0.3535f
C78 a_750_97# S1 0.06402f
C79 a_668_97# A3 0.00336f
C80 a_750_97# A3 0.03468f
C81 a_757_363# S1 0.00167f
C82 S0 VPB 0.31074f
C83 a_757_363# A3 0.03242f
C84 a_277_47# a_27_47# 0.08713f
C85 a_247_21# A1 0
C86 VPB a_247_21# 0.22615f
C87 a_668_97# a_750_97# 0.04699f
C88 a_1290_413# VGND 0.06655f
C89 a_757_363# a_750_97# 0.13413f
C90 VPWR a_1478_413# 0.21159f
C91 A0 a_193_47# 0
C92 a_27_47# A1 0.04037f
C93 VPB a_27_47# 0.00324f
C94 A2 a_834_97# 0.044f
C95 a_750_97# A0 0
C96 A2 VPWR 0.0129f
C97 a_247_21# a_1290_413# 0.00705f
C98 a_750_97# a_27_413# 0
C99 VPWR X 0.05976f
C100 a_277_47# a_834_97# 0.04444f
C101 a_193_413# VGND 0
C102 S1 a_1478_413# 0.00564f
C103 a_277_47# VPWR 0.05749f
C104 A0 a_27_413# 0.0494f
C105 VPB a_834_97# 0.00426f
C106 a_750_97# a_1478_413# 0.1464f
C107 VPWR A1 0.01712f
C108 VPB VPWR 0.25376f
C109 S0 VGND 0.06981f
C110 a_923_363# a_1290_413# 0
C111 A2 S1 0.06915f
C112 S0 a_193_413# 0.01921f
C113 a_247_21# VGND 0.09416f
C114 A2 A3 0.15492f
C115 a_247_21# a_193_413# 0.09162f
C116 a_668_97# A2 0
C117 A2 a_750_97# 0.01648f
C118 a_27_47# VGND 0.23068f
C119 a_757_363# A2 0.03669f
C120 S1 X 0
C121 a_834_97# a_1290_413# 0.01257f
C122 a_277_47# a_193_47# 0
C123 a_277_47# S1 0.06504f
C124 S0 a_247_21# 0.4004f
C125 a_277_47# A3 0.0121f
C126 VPWR a_1290_413# 0.08305f
C127 a_750_97# X 0
C128 a_277_47# a_668_97# 0.02235f
C129 a_277_47# a_750_97# 0.26754f
C130 S0 a_27_47# 0.01935f
C131 VPB S1 0.21534f
C132 VPB A3 0.07252f
C133 a_277_47# a_757_363# 0
C134 a_247_21# a_27_47# 0.04622f
C135 a_750_97# A1 0
C136 a_668_97# VPB 0.00146f
C137 VPB a_750_97# 0.06387f
C138 a_757_363# VPB 0.02759f
C139 a_277_47# A0 0.05427f
C140 a_834_97# VGND 0.09588f
C141 VPWR VGND 0.05901f
C142 A0 A1 0.14205f
C143 S1 a_1290_413# 0.16172f
C144 VPB A0 0.08019f
C145 a_193_413# VPWR 0.18514f
C146 a_277_47# a_27_413# 0.05408f
C147 A3 a_1290_413# 0
C148 a_668_97# a_1290_413# 0
C149 a_750_97# a_1290_413# 0.17755f
C150 a_27_413# A1 0.04273f
C151 VPB a_27_413# 0.02695f
C152 S0 a_834_97# 0
C153 a_757_363# a_1290_413# 0.00987f
C154 a_1478_413# X 0.12975f
C155 a_247_21# a_834_97# 0.02884f
C156 S0 VPWR 0.06889f
C157 VGND VNB 1.06567f
C158 X VNB 0.09065f
C159 S1 VNB 0.25399f
C160 A2 VNB 0.07902f
C161 A3 VNB 0.08575f
C162 S0 VNB 0.36537f
C163 VPWR VNB 0.84115f
C164 A0 VNB 0.06908f
C165 A1 VNB 0.14237f
C166 VPB VNB 1.9337f
C167 a_834_97# VNB 0.02352f
C168 a_668_97# VNB 0.01818f
C169 a_27_47# VNB 0.03906f
C170 a_1478_413# VNB 0.12775f
C171 a_1290_413# VNB 0.17636f
C172 a_750_97# VNB 0.03599f
C173 a_757_363# VNB 0.00277f
C174 a_277_47# VNB 0.06912f
C175 a_247_21# VNB 0.2708f
C176 a_27_413# VNB 0.02454f
.ends

.subckt ZMUX4 Z3_1 Z2_1 Z1_1 Z0_1 y1 y0 Z3_0 Z2_0 Z1_0 Z0_0 Zo_1 Zo_0 sky130_fd_sc_hd__mux4_1_1/a_757_363#
+ sky130_fd_sc_hd__mux4_1_0/a_834_97# sky130_fd_sc_hd__mux4_1_0/a_27_47# sky130_fd_sc_hd__mux4_1_0/a_247_21#
+ sky130_fd_sc_hd__mux4_1_0/a_668_97# sky130_fd_sc_hd__mux4_1_0/a_923_363# sky130_fd_sc_hd__mux4_1_0/a_277_47#
+ sky130_fd_sc_hd__mux4_1_1/a_834_97# sky130_fd_sc_hd__mux4_1_1/a_923_363# sky130_fd_sc_hd__mux4_1_0/a_1290_413#
+ sky130_fd_sc_hd__mux4_1_1/a_1290_413# sky130_fd_sc_hd__mux4_1_1/a_247_21# sky130_fd_sc_hd__mux4_1_1/a_27_47#
+ sky130_fd_sc_hd__mux4_1_0/a_1478_413# sky130_fd_sc_hd__mux4_1_1/a_668_97# sky130_fd_sc_hd__mux4_1_0/a_750_97#
+ sky130_fd_sc_hd__mux4_1_0/a_27_413# sky130_fd_sc_hd__mux4_1_1/a_1478_413# sky130_fd_sc_hd__mux4_1_1/a_277_47#
+ sky130_fd_sc_hd__mux4_1_0/a_193_47# sky130_fd_sc_hd__mux4_1_1/a_750_97# sky130_fd_sc_hd__mux4_1_1/a_27_413#
+ VDD sky130_fd_sc_hd__mux4_1_0/a_193_413# sky130_fd_sc_hd__mux4_1_1/a_193_47# sky130_fd_sc_hd__mux4_1_0/a_757_363#
+ sky130_fd_sc_hd__mux4_1_1/a_193_413# GND
Xsky130_fd_sc_hd__mux4_1_0 Z3_1 Z2_1 Z1_1 Z0_1 y0 y1 GND GND VDD VDD Zo_1 sky130_fd_sc_hd__mux4_1_0/a_1290_413#
+ sky130_fd_sc_hd__mux4_1_0/a_757_363# sky130_fd_sc_hd__mux4_1_0/a_1478_413# sky130_fd_sc_hd__mux4_1_0/a_277_47#
+ sky130_fd_sc_hd__mux4_1_0/a_750_97# sky130_fd_sc_hd__mux4_1_0/a_27_413# sky130_fd_sc_hd__mux4_1_0/a_923_363#
+ sky130_fd_sc_hd__mux4_1_0/a_193_47# sky130_fd_sc_hd__mux4_1_0/a_834_97# sky130_fd_sc_hd__mux4_1_0/a_247_21#
+ sky130_fd_sc_hd__mux4_1_0/a_668_97# sky130_fd_sc_hd__mux4_1_0/a_193_413# sky130_fd_sc_hd__mux4_1_0/a_27_47#
+ sky130_fd_sc_hd__mux4_1
Xsky130_fd_sc_hd__mux4_1_1 Z3_0 Z2_0 Z1_0 Z0_0 y0 y1 GND GND VDD VDD Zo_0 sky130_fd_sc_hd__mux4_1_1/a_1290_413#
+ sky130_fd_sc_hd__mux4_1_1/a_757_363# sky130_fd_sc_hd__mux4_1_1/a_1478_413# sky130_fd_sc_hd__mux4_1_1/a_277_47#
+ sky130_fd_sc_hd__mux4_1_1/a_750_97# sky130_fd_sc_hd__mux4_1_1/a_27_413# sky130_fd_sc_hd__mux4_1_1/a_923_363#
+ sky130_fd_sc_hd__mux4_1_1/a_193_47# sky130_fd_sc_hd__mux4_1_1/a_834_97# sky130_fd_sc_hd__mux4_1_1/a_247_21#
+ sky130_fd_sc_hd__mux4_1_1/a_668_97# sky130_fd_sc_hd__mux4_1_1/a_193_413# sky130_fd_sc_hd__mux4_1_1/a_27_47#
+ sky130_fd_sc_hd__mux4_1
C0 sky130_fd_sc_hd__mux4_1_0/a_750_97# y1 0.0323f
C1 sky130_fd_sc_hd__mux4_1_1/a_27_47# y0 0.00304f
C2 sky130_fd_sc_hd__mux4_1_1/a_247_21# Z1_0 -0
C3 sky130_fd_sc_hd__mux4_1_0/a_834_97# y1 0.00297f
C4 sky130_fd_sc_hd__mux4_1_1/a_668_97# y0 0.00652f
C5 sky130_fd_sc_hd__mux4_1_0/a_757_363# Zo_1 0
C6 Zo_1 sky130_fd_sc_hd__mux4_1_0/a_27_413# 0
C7 Zo_0 sky130_fd_sc_hd__mux4_1_1/a_277_47# 0.00204f
C8 VDD sky130_fd_sc_hd__mux4_1_0/a_193_413# 0
C9 Z1_1 sky130_fd_sc_hd__mux4_1_1/a_277_47# 0
C10 Z0_0 Z0_1 0.00519f
C11 Z0_1 sky130_fd_sc_hd__mux4_1_0/a_757_363# 0
C12 sky130_fd_sc_hd__mux4_1_0/a_750_97# Zo_1 0.00376f
C13 sky130_fd_sc_hd__mux4_1_0/a_277_47# y1 0.03541f
C14 VDD Zo_0 0.10092f
C15 y0 sky130_fd_sc_hd__mux4_1_1/a_193_47# 0
C16 sky130_fd_sc_hd__mux4_1_0/a_750_97# sky130_fd_sc_hd__mux4_1_0/a_247_21# -0
C17 Z0_0 sky130_fd_sc_hd__mux4_1_1/a_834_97# 0
C18 VDD Z1_1 0.00324f
C19 sky130_fd_sc_hd__mux4_1_1/a_1290_413# y0 0
C20 Z0_0 y0 0.00343f
C21 sky130_fd_sc_hd__mux4_1_0/a_757_363# y0 0.00144f
C22 sky130_fd_sc_hd__mux4_1_1/a_1478_413# y0 0
C23 sky130_fd_sc_hd__mux4_1_0/a_27_413# y0 0.00124f
C24 Z2_0 sky130_fd_sc_hd__mux4_1_0/a_27_47# 0
C25 VDD sky130_fd_sc_hd__mux4_1_0/a_193_47# -0
C26 sky130_fd_sc_hd__mux4_1_0/a_750_97# Z0_1 0.0326f
C27 sky130_fd_sc_hd__mux4_1_0/a_27_47# VDD -0.00116f
C28 VDD sky130_fd_sc_hd__mux4_1_1/a_757_363# 0
C29 Z3_0 y0 0.00233f
C30 sky130_fd_sc_hd__mux4_1_1/a_247_21# sky130_fd_sc_hd__mux4_1_1/a_1290_413# -0.00346f
C31 sky130_fd_sc_hd__mux4_1_1/a_247_21# Z0_0 0.01438f
C32 sky130_fd_sc_hd__mux4_1_1/a_750_97# sky130_fd_sc_hd__mux4_1_1/a_193_413# -0
C33 sky130_fd_sc_hd__mux4_1_0/a_834_97# Z0_1 0
C34 VDD Z3_1 0.01422f
C35 sky130_fd_sc_hd__mux4_1_0/a_750_97# y0 0.01394f
C36 Z2_1 sky130_fd_sc_hd__mux4_1_1/a_27_47# 0
C37 sky130_fd_sc_hd__mux4_1_0/a_277_47# Zo_1 0
C38 sky130_fd_sc_hd__mux4_1_0/a_834_97# y0 0.00195f
C39 sky130_fd_sc_hd__mux4_1_1/a_247_21# Z3_0 0.01113f
C40 sky130_fd_sc_hd__mux4_1_0/a_277_47# Z0_1 0.01691f
C41 Z3_1 sky130_fd_sc_hd__mux4_1_0/a_193_413# 0.00232f
C42 sky130_fd_sc_hd__mux4_1_0/a_834_97# sky130_fd_sc_hd__mux4_1_1/a_247_21# 0
C43 y1 sky130_fd_sc_hd__mux4_1_0/a_668_97# 0.00214f
C44 VDD sky130_fd_sc_hd__mux4_1_0/a_1478_413# 0.01676f
C45 sky130_fd_sc_hd__mux4_1_0/a_277_47# y0 0.01559f
C46 Z1_1 Z3_1 0
C47 Z2_1 sky130_fd_sc_hd__mux4_1_0/a_27_413# 0.00671f
C48 Z2_0 sky130_fd_sc_hd__mux4_1_1/a_27_413# 0.00315f
C49 sky130_fd_sc_hd__mux4_1_1/a_750_97# sky130_fd_sc_hd__mux4_1_1/a_277_47# -0.03673f
C50 sky130_fd_sc_hd__mux4_1_1/a_277_47# y1 0.03426f
C51 VDD sky130_fd_sc_hd__mux4_1_1/a_27_413# 0
C52 sky130_fd_sc_hd__mux4_1_1/a_247_21# sky130_fd_sc_hd__mux4_1_0/a_277_47# 0
C53 Z3_1 sky130_fd_sc_hd__mux4_1_0/a_193_47# 0
C54 sky130_fd_sc_hd__mux4_1_0/a_27_47# Z3_1 0.00247f
C55 sky130_fd_sc_hd__mux4_1_1/a_193_413# y0 0
C56 Z2_0 sky130_fd_sc_hd__mux4_1_1/a_750_97# -0
C57 Z2_0 y1 0
C58 sky130_fd_sc_hd__mux4_1_0/a_750_97# Z2_1 -0
C59 VDD sky130_fd_sc_hd__mux4_1_1/a_750_97# 0.00434f
C60 VDD y1 0.0874f
C61 Z1_1 sky130_fd_sc_hd__mux4_1_0/a_1478_413# 0
C62 sky130_fd_sc_hd__mux4_1_1/a_277_47# sky130_fd_sc_hd__mux4_1_0/a_247_21# 0
C63 sky130_fd_sc_hd__mux4_1_1/a_1290_413# sky130_fd_sc_hd__mux4_1_0/a_1290_413# 0.00809f
C64 sky130_fd_sc_hd__mux4_1_1/a_1478_413# sky130_fd_sc_hd__mux4_1_0/a_1290_413# 0
C65 y0 sky130_fd_sc_hd__mux4_1_0/a_668_97# 0.00652f
C66 Z2_1 sky130_fd_sc_hd__mux4_1_0/a_277_47# 0
C67 VDD Zo_1 0.12083f
C68 Z0_1 sky130_fd_sc_hd__mux4_1_1/a_277_47# 0
C69 VDD sky130_fd_sc_hd__mux4_1_0/a_247_21# -0.01115f
C70 Zo_0 sky130_fd_sc_hd__mux4_1_1/a_750_97# 0
C71 Zo_0 y1 0.00151f
C72 sky130_fd_sc_hd__mux4_1_1/a_1290_413# Z1_0 0.00381f
C73 Z1_0 Z0_0 0.02447f
C74 Z1_1 y1 0.02111f
C75 sky130_fd_sc_hd__mux4_1_1/a_277_47# y0 0.01422f
C76 sky130_fd_sc_hd__mux4_1_1/a_247_21# sky130_fd_sc_hd__mux4_1_0/a_668_97# 0
C77 VDD Z0_1 0.00332f
C78 sky130_fd_sc_hd__mux4_1_1/a_750_97# sky130_fd_sc_hd__mux4_1_1/a_757_363# -0
C79 Zo_1 sky130_fd_sc_hd__mux4_1_0/a_193_413# 0
C80 Z2_0 y0 0.0013f
C81 Z1_0 Z3_0 0
C82 sky130_fd_sc_hd__mux4_1_1/a_247_21# sky130_fd_sc_hd__mux4_1_1/a_277_47# 0
C83 VDD y0 0.07213f
C84 Z3_1 y1 0
C85 Z3_0 sky130_fd_sc_hd__mux4_1_1/a_27_47# 0.0048f
C86 sky130_fd_sc_hd__mux4_1_0/a_834_97# Z1_0 0
C87 Z1_1 Zo_1 0
C88 Z2_0 sky130_fd_sc_hd__mux4_1_1/a_247_21# -0
C89 sky130_fd_sc_hd__mux4_1_1/a_247_21# VDD -0.01162f
C90 Z1_1 sky130_fd_sc_hd__mux4_1_0/a_247_21# 0
C91 y0 sky130_fd_sc_hd__mux4_1_0/a_193_413# 0
C92 sky130_fd_sc_hd__mux4_1_1/a_1290_413# Z0_0 -0
C93 Z1_1 Z0_1 0.02385f
C94 VDD sky130_fd_sc_hd__mux4_1_0/a_923_363# 0
C95 Zo_0 sky130_fd_sc_hd__mux4_1_1/a_834_97# 0
C96 Z1_0 sky130_fd_sc_hd__mux4_1_0/a_277_47# 0
C97 Z3_1 sky130_fd_sc_hd__mux4_1_0/a_247_21# 0.00198f
C98 y1 sky130_fd_sc_hd__mux4_1_0/a_1478_413# 0.00441f
C99 Zo_0 y0 0
C100 Z1_1 sky130_fd_sc_hd__mux4_1_1/a_834_97# 0
C101 Z3_0 sky130_fd_sc_hd__mux4_1_1/a_193_47# 0
C102 Z1_1 y0 0.00213f
C103 sky130_fd_sc_hd__mux4_1_1/a_1290_413# Z3_0 0
C104 Z0_0 Z3_0 0
C105 sky130_fd_sc_hd__mux4_1_1/a_1478_413# Z3_0 0
C106 Z0_1 Z3_1 0.00223f
C107 sky130_fd_sc_hd__mux4_1_1/a_750_97# sky130_fd_sc_hd__mux4_1_1/a_27_413# -0
C108 sky130_fd_sc_hd__mux4_1_0/a_750_97# sky130_fd_sc_hd__mux4_1_0/a_757_363# -0
C109 y0 sky130_fd_sc_hd__mux4_1_0/a_193_47# 0
C110 sky130_fd_sc_hd__mux4_1_0/a_27_47# y0 0.00304f
C111 sky130_fd_sc_hd__mux4_1_1/a_757_363# y0 0.00144f
C112 Z2_0 Z2_1 0.00488f
C113 sky130_fd_sc_hd__mux4_1_1/a_247_21# Zo_0 0
C114 sky130_fd_sc_hd__mux4_1_0/a_750_97# sky130_fd_sc_hd__mux4_1_0/a_27_413# -0
C115 VDD Z2_1 0.01261f
C116 sky130_fd_sc_hd__mux4_1_0/a_834_97# Z0_0 0
C117 Z3_1 y0 0.00374f
C118 sky130_fd_sc_hd__mux4_1_1/a_750_97# y1 0.02852f
C119 Zo_1 sky130_fd_sc_hd__mux4_1_0/a_1478_413# 0.00284f
C120 VDD sky130_fd_sc_hd__mux4_1_1/a_923_363# 0
C121 sky130_fd_sc_hd__mux4_1_0/a_27_47# sky130_fd_sc_hd__mux4_1_1/a_247_21# 0
C122 sky130_fd_sc_hd__mux4_1_1/a_1290_413# sky130_fd_sc_hd__mux4_1_0/a_277_47# 0
C123 Z0_0 sky130_fd_sc_hd__mux4_1_0/a_277_47# 0
C124 sky130_fd_sc_hd__mux4_1_0/a_1290_413# sky130_fd_sc_hd__mux4_1_1/a_277_47# 0
C125 Zo_1 y1 0.00173f
C126 y0 sky130_fd_sc_hd__mux4_1_0/a_1478_413# 0
C127 y1 sky130_fd_sc_hd__mux4_1_0/a_247_21# 0.00188f
C128 VDD sky130_fd_sc_hd__mux4_1_0/a_1290_413# 0.00602f
C129 sky130_fd_sc_hd__mux4_1_0/a_750_97# sky130_fd_sc_hd__mux4_1_0/a_277_47# -0.03673f
C130 Z1_0 sky130_fd_sc_hd__mux4_1_1/a_277_47# 0.02335f
C131 y0 sky130_fd_sc_hd__mux4_1_1/a_27_413# 0.00124f
C132 sky130_fd_sc_hd__mux4_1_0/a_27_47# Z2_1 0.00279f
C133 Z0_1 y1 0.003f
C134 Z2_1 Z3_1 0.01958f
C135 Z3_0 sky130_fd_sc_hd__mux4_1_1/a_193_413# 0.00148f
C136 Z2_0 Z1_0 0
C137 sky130_fd_sc_hd__mux4_1_1/a_834_97# y1 0.00297f
C138 VDD Z1_0 0.00139f
C139 sky130_fd_sc_hd__mux4_1_1/a_750_97# y0 0.01387f
C140 y1 y0 0.06431f
C141 Zo_1 sky130_fd_sc_hd__mux4_1_0/a_247_21# 0
C142 Z2_0 sky130_fd_sc_hd__mux4_1_1/a_27_47# 0.00529f
C143 VDD sky130_fd_sc_hd__mux4_1_1/a_27_47# -0.00119f
C144 Z0_0 sky130_fd_sc_hd__mux4_1_0/a_668_97# 0
C145 sky130_fd_sc_hd__mux4_1_1/a_247_21# sky130_fd_sc_hd__mux4_1_1/a_750_97# -0
C146 sky130_fd_sc_hd__mux4_1_1/a_247_21# y1 0.00134f
C147 Z0_1 Zo_1 0
C148 Z1_1 sky130_fd_sc_hd__mux4_1_0/a_1290_413# 0
C149 Z0_1 sky130_fd_sc_hd__mux4_1_0/a_247_21# 0.00163f
C150 Z0_0 sky130_fd_sc_hd__mux4_1_1/a_277_47# 0.02323f
C151 Zo_1 y0 0
C152 sky130_fd_sc_hd__mux4_1_1/a_1478_413# sky130_fd_sc_hd__mux4_1_1/a_277_47# 0
C153 sky130_fd_sc_hd__mux4_1_1/a_834_97# sky130_fd_sc_hd__mux4_1_0/a_247_21# 0
C154 sky130_fd_sc_hd__mux4_1_0/a_247_21# y0 0.04766f
C155 Z1_0 Zo_0 0
C156 Z1_0 Z1_1 0.00484f
C157 Z2_0 sky130_fd_sc_hd__mux4_1_1/a_1290_413# 0
C158 Z3_0 sky130_fd_sc_hd__mux4_1_1/a_277_47# 0.00405f
C159 VDD sky130_fd_sc_hd__mux4_1_1/a_193_47# -0
C160 Z2_0 Z0_0 0
C161 sky130_fd_sc_hd__mux4_1_1/a_1290_413# VDD 0.00602f
C162 Z0_1 sky130_fd_sc_hd__mux4_1_1/a_834_97# 0
C163 VDD sky130_fd_sc_hd__mux4_1_0/a_757_363# 0
C164 VDD Z0_0 0.00228f
C165 sky130_fd_sc_hd__mux4_1_1/a_1478_413# VDD 0.01663f
C166 Z0_1 y0 0.00618f
C167 Zo_0 sky130_fd_sc_hd__mux4_1_1/a_27_47# 0
C168 sky130_fd_sc_hd__mux4_1_1/a_247_21# sky130_fd_sc_hd__mux4_1_0/a_247_21# 0.01287f
C169 VDD sky130_fd_sc_hd__mux4_1_0/a_27_413# 0
C170 Z1_0 sky130_fd_sc_hd__mux4_1_1/a_757_363# 0
C171 Zo_0 sky130_fd_sc_hd__mux4_1_1/a_668_97# 0
C172 Z2_0 Z3_0 0.01741f
C173 sky130_fd_sc_hd__mux4_1_1/a_834_97# y0 0.00195f
C174 Z2_1 y1 0
C175 VDD Z3_0 0.01034f
C176 sky130_fd_sc_hd__mux4_1_0/a_923_363# Zo_1 0
C177 sky130_fd_sc_hd__mux4_1_0/a_750_97# VDD 0.00363f
C178 Z3_1 sky130_fd_sc_hd__mux4_1_1/a_27_47# 0
C179 sky130_fd_sc_hd__mux4_1_1/a_247_21# y0 0.04579f
C180 sky130_fd_sc_hd__mux4_1_1/a_1290_413# Zo_0 0
C181 Zo_0 Z0_0 0
C182 sky130_fd_sc_hd__mux4_1_1/a_1478_413# Zo_0 0.00463f
C183 Z1_1 sky130_fd_sc_hd__mux4_1_0/a_757_363# 0
C184 sky130_fd_sc_hd__mux4_1_0/a_750_97# sky130_fd_sc_hd__mux4_1_0/a_193_413# -0
C185 VDD sky130_fd_sc_hd__mux4_1_0/a_277_47# 0.00177f
C186 Z0_0 sky130_fd_sc_hd__mux4_1_1/a_757_363# 0
C187 sky130_fd_sc_hd__mux4_1_0/a_1290_413# y1 0.01271f
C188 sky130_fd_sc_hd__mux4_1_0/a_750_97# Z1_1 0.02716f
C189 Z3_1 sky130_fd_sc_hd__mux4_1_0/a_27_413# 0.0037f
C190 sky130_fd_sc_hd__mux4_1_0/a_27_47# Z3_0 0
C191 sky130_fd_sc_hd__mux4_1_0/a_834_97# Z1_1 0
C192 Z2_1 y0 0.0012f
C193 Z3_1 Z3_0 0.00488f
C194 VDD sky130_fd_sc_hd__mux4_1_1/a_193_413# 0
C195 Z1_0 sky130_fd_sc_hd__mux4_1_1/a_750_97# 0.01745f
C196 Z1_0 y1 0.01735f
C197 sky130_fd_sc_hd__mux4_1_0/a_750_97# Z3_1 0
C198 sky130_fd_sc_hd__mux4_1_0/a_1290_413# Zo_1 0
C199 sky130_fd_sc_hd__mux4_1_1/a_668_97# y1 0.00214f
C200 Z1_1 sky130_fd_sc_hd__mux4_1_0/a_277_47# 0.01645f
C201 sky130_fd_sc_hd__mux4_1_1/a_1290_413# sky130_fd_sc_hd__mux4_1_0/a_1478_413# 0
C202 sky130_fd_sc_hd__mux4_1_1/a_1478_413# sky130_fd_sc_hd__mux4_1_0/a_1478_413# 0.00573f
C203 VDD sky130_fd_sc_hd__mux4_1_0/a_668_97# -0
C204 sky130_fd_sc_hd__mux4_1_0/a_277_47# Z3_1 0.00548f
C205 sky130_fd_sc_hd__mux4_1_0/a_1290_413# y0 0
C206 Z2_0 sky130_fd_sc_hd__mux4_1_1/a_277_47# 0
C207 Z3_0 sky130_fd_sc_hd__mux4_1_1/a_27_413# 0.0019f
C208 VDD sky130_fd_sc_hd__mux4_1_1/a_277_47# 0.0017f
C209 Z0_0 sky130_fd_sc_hd__mux4_1_1/a_750_97# 0.0184f
C210 sky130_fd_sc_hd__mux4_1_1/a_27_47# sky130_fd_sc_hd__mux4_1_0/a_247_21# 0
C211 sky130_fd_sc_hd__mux4_1_1/a_1290_413# y1 0.01627f
C212 Z0_0 y1 0.00306f
C213 sky130_fd_sc_hd__mux4_1_1/a_1478_413# y1 0.00429f
C214 sky130_fd_sc_hd__mux4_1_1/a_668_97# sky130_fd_sc_hd__mux4_1_0/a_247_21# 0
C215 Z1_0 sky130_fd_sc_hd__mux4_1_1/a_834_97# 0
C216 Z1_0 y0 0.00193f
C217 Z2_0 VDD 0.00989f
C218 sky130_fd_sc_hd__mux4_1_1/a_750_97# Z3_0 0
C219 Z3_0 y1 0
C220 Z0_1 sky130_fd_sc_hd__mux4_1_1/a_668_97# 0
C221 Zo_0 GND 0.02344f
C222 y1 GND 0.09228f
C223 Z1_0 GND -0.00299f
C224 Z0_0 GND -0.00238f
C225 y0 GND 0.11308f
C226 Z3_0 GND 0.01051f
C227 Z2_0 GND 0.02004f
C228 sky130_fd_sc_hd__mux4_1_1/a_193_47# GND 0
C229 sky130_fd_sc_hd__mux4_1_1/a_1478_413# GND 0.00239f
C230 sky130_fd_sc_hd__mux4_1_1/a_1290_413# GND 0.00152f
C231 sky130_fd_sc_hd__mux4_1_1/a_277_47# GND 0
C232 sky130_fd_sc_hd__mux4_1_1/a_247_21# GND 0.00168f
C233 sky130_fd_sc_hd__mux4_1_1/a_193_413# GND -0
C234 sky130_fd_sc_hd__mux4_1_1/a_27_413# GND -0.00115f
C235 Zo_1 GND 0.00155f
C236 Z1_1 GND -0.00409f
C237 Z0_1 GND -0.00438f
C238 Z3_1 GND 0.00494f
C239 Z2_1 GND 0.01377f
C240 sky130_fd_sc_hd__mux4_1_0/a_834_97# GND 0
C241 sky130_fd_sc_hd__mux4_1_0/a_668_97# GND 0
C242 sky130_fd_sc_hd__mux4_1_0/a_193_47# GND -0
C243 sky130_fd_sc_hd__mux4_1_0/a_27_47# GND -0
C244 sky130_fd_sc_hd__mux4_1_0/a_1478_413# GND 0.00245f
C245 sky130_fd_sc_hd__mux4_1_0/a_1290_413# GND 0.00154f
C246 sky130_fd_sc_hd__mux4_1_0/a_750_97# GND 0
C247 sky130_fd_sc_hd__mux4_1_0/a_277_47# GND 0
C248 sky130_fd_sc_hd__mux4_1_0/a_247_21# GND 0.00198f
C249 sky130_fd_sc_hd__mux4_1_0/a_193_413# GND -0
C250 sky130_fd_sc_hd__mux4_1_0/a_27_413# GND -0.0011f
C251 VDD GND -0.38427f
.ends

.subckt sky130_fd_sc_hd__nand2_1 A B VGND VNB VPB VPWR Y a_113_47#
X0 VPWR A Y VPB sky130_fd_pr__pfet_01v8_hvt ad=0.26 pd=2.52 as=0.135 ps=1.27 w=1 l=0.15
X1 Y A a_113_47# VNB sky130_fd_pr__nfet_01v8 ad=0.169 pd=1.82 as=0.08775 ps=0.92 w=0.65 l=0.15
X2 a_113_47# B VGND VNB sky130_fd_pr__nfet_01v8 ad=0.08775 pd=0.92 as=0.169 ps=1.82 w=0.65 l=0.15
X3 Y B VPWR VPB sky130_fd_pr__pfet_01v8_hvt ad=0.135 pd=1.27 as=0.26 ps=2.52 w=1 l=0.15
C0 VPWR B 0.05148f
C1 VPWR a_113_47# 0
C2 A VPB 0.03788f
C3 VPWR Y 0.21151f
C4 VGND B 0.0544f
C5 VGND a_113_47# 0.00201f
C6 VGND Y 0.139f
C7 B VPB 0.03907f
C8 VPWR VGND 0.03219f
C9 Y VPB 0.00618f
C10 A B 0.05096f
C11 VPWR VPB 0.05574f
C12 A Y 0.08548f
C13 VPWR A 0.04807f
C14 VGND VPB 0.0044f
C15 B Y 0.04807f
C16 Y a_113_47# 0.00937f
C17 VGND A 0.00949f
C18 VGND VNB 0.23154f
C19 Y VNB 0.05566f
C20 VPWR VNB 0.24021f
C21 A VNB 0.10995f
C22 B VNB 0.11267f
C23 VPB VNB 0.33898f
.ends

.subckt sky130_fd_sc_hd__a21oi_2 A1 A2 B1 VGND VNB VPB VPWR Y a_114_47# a_27_297#
+ a_285_47#
X0 VGND A2 a_285_47# VNB sky130_fd_pr__nfet_01v8 ad=0.10725 pd=0.98 as=0.06825 ps=0.86 w=0.65 l=0.15
X1 VGND B1 Y VNB sky130_fd_pr__nfet_01v8 ad=0.26 pd=2.1 as=0.08775 ps=0.92 w=0.65 l=0.15
X2 Y A1 a_114_47# VNB sky130_fd_pr__nfet_01v8 ad=0.091 pd=0.93 as=0.08937 ps=0.925 w=0.65 l=0.15
X3 a_114_47# A2 VGND VNB sky130_fd_pr__nfet_01v8 ad=0.08937 pd=0.925 as=0.18525 ps=1.87 w=0.65 l=0.15
X4 a_27_297# B1 Y VPB sky130_fd_pr__pfet_01v8_hvt ad=0.36 pd=2.72 as=0.135 ps=1.27 w=1 l=0.15
X5 a_27_297# A1 VPWR VPB sky130_fd_pr__pfet_01v8_hvt ad=0.14 pd=1.28 as=0.14 ps=1.28 w=1 l=0.15
X6 Y B1 a_27_297# VPB sky130_fd_pr__pfet_01v8_hvt ad=0.135 pd=1.27 as=0.135 ps=1.27 w=1 l=0.15
X7 VPWR A2 a_27_297# VPB sky130_fd_pr__pfet_01v8_hvt ad=0.14 pd=1.28 as=0.28 ps=2.56 w=1 l=0.15
X8 a_27_297# A2 VPWR VPB sky130_fd_pr__pfet_01v8_hvt ad=0.135 pd=1.27 as=0.135 ps=1.27 w=1 l=0.15
X9 VPWR A1 a_27_297# VPB sky130_fd_pr__pfet_01v8_hvt ad=0.135 pd=1.27 as=0.14 ps=1.28 w=1 l=0.15
X10 a_285_47# A1 Y VNB sky130_fd_pr__nfet_01v8 ad=0.06825 pd=0.86 as=0.091 ps=0.93 w=0.65 l=0.15
X11 Y B1 VGND VNB sky130_fd_pr__nfet_01v8 ad=0.08775 pd=0.92 as=0.10725 ps=0.98 w=0.65 l=0.15
C0 VPWR A2 0.04378f
C1 a_27_297# B1 0.05562f
C2 a_285_47# Y 0.00821f
C3 VPWR A1 0.03023f
C4 Y B1 0.12053f
C5 VPB VGND 0.00751f
C6 A2 a_114_47# 0.00288f
C7 a_27_297# Y 0.0949f
C8 A1 a_114_47# 0
C9 VGND a_285_47# 0.0055f
C10 VGND B1 0.0612f
C11 VGND a_27_297# 0.01285f
C12 VPWR a_114_47# 0.00124f
C13 VGND Y 0.25217f
C14 VPB A2 0.06904f
C15 VPB A1 0.05386f
C16 a_285_47# A2 0
C17 A2 B1 0.05951f
C18 A1 B1 0
C19 VPB VPWR 0.07386f
C20 a_27_297# A2 0.18014f
C21 A2 Y 0.07181f
C22 A1 a_27_297# 0.02656f
C23 A1 Y 0.05894f
C24 VPWR a_285_47# 0
C25 VPWR B1 0.01907f
C26 VGND A2 0.0735f
C27 VPWR a_27_297# 0.38147f
C28 VGND A1 0.03173f
C29 VPWR Y 0.01277f
C30 Y a_114_47# 0.00441f
C31 VPWR VGND 0.06498f
C32 VPB B1 0.07973f
C33 A1 A2 0.22587f
C34 VGND a_114_47# 0.01235f
C35 VPB a_27_297# 0.01806f
C36 VPB Y 0.00724f
C37 VGND VNB 0.43881f
C38 Y VNB 0.02554f
C39 VPWR VNB 0.31797f
C40 B1 VNB 0.1922f
C41 A1 VNB 0.10659f
C42 A2 VNB 0.1723f
C43 VPB VNB 0.69336f
C44 a_27_297# VNB 0.04628f
.ends

.subckt sky130_fd_sc_hd__inv_2 A VGND VNB VPB VPWR Y
X0 Y A VPWR VPB sky130_fd_pr__pfet_01v8_hvt ad=0.135 pd=1.27 as=0.26 ps=2.52 w=1 l=0.15
X1 VGND A Y VNB sky130_fd_pr__nfet_01v8 ad=0.169 pd=1.82 as=0.08775 ps=0.92 w=0.65 l=0.15
X2 Y A VGND VNB sky130_fd_pr__nfet_01v8 ad=0.08775 pd=0.92 as=0.169 ps=1.82 w=0.65 l=0.15
X3 VPWR A Y VPB sky130_fd_pr__pfet_01v8_hvt ad=0.26 pd=2.52 as=0.135 ps=1.27 w=1 l=0.15
C0 VPWR Y 0.20921f
C1 VGND VPB 0.00649f
C2 A VPB 0.07418f
C3 A VGND 0.0686f
C4 Y VPB 0.0061f
C5 Y VGND 0.1547f
C6 VPWR VPB 0.05694f
C7 A Y 0.08939f
C8 VPWR VGND 0.04227f
C9 VPWR A 0.07032f
C10 VGND VNB 0.26392f
C11 Y VNB 0.03316f
C12 VPWR VNB 0.24114f
C13 A VNB 0.19622f
C14 VPB VNB 0.33898f
.ends

.subckt sky130_fd_sc_hd__nor2_2 A B VGND VNB VPB VPWR Y a_27_297#
X0 Y B a_27_297# VPB sky130_fd_pr__pfet_01v8_hvt ad=0.135 pd=1.27 as=0.135 ps=1.27 w=1 l=0.15
X1 Y B VGND VNB sky130_fd_pr__nfet_01v8 ad=0.08775 pd=0.92 as=0.08775 ps=0.92 w=0.65 l=0.15
X2 a_27_297# A VPWR VPB sky130_fd_pr__pfet_01v8_hvt ad=0.135 pd=1.27 as=0.135 ps=1.27 w=1 l=0.15
X3 VGND A Y VNB sky130_fd_pr__nfet_01v8 ad=0.08775 pd=0.92 as=0.08775 ps=0.92 w=0.65 l=0.15
X4 Y A VGND VNB sky130_fd_pr__nfet_01v8 ad=0.08775 pd=0.92 as=0.182 ps=1.86 w=0.65 l=0.15
X5 VGND B Y VNB sky130_fd_pr__nfet_01v8 ad=0.169 pd=1.82 as=0.08775 ps=0.92 w=0.65 l=0.15
X6 VPWR A a_27_297# VPB sky130_fd_pr__pfet_01v8_hvt ad=0.135 pd=1.27 as=0.28 ps=2.56 w=1 l=0.15
X7 a_27_297# B Y VPB sky130_fd_pr__pfet_01v8_hvt ad=0.26 pd=2.52 as=0.135 ps=1.27 w=1 l=0.15
C0 VPWR Y 0.01278f
C1 VPB Y 0.00961f
C2 A B 0.07116f
C3 a_27_297# B 0.05029f
C4 a_27_297# A 0.09478f
C5 B Y 0.17937f
C6 VGND VPWR 0.04668f
C7 A Y 0.05233f
C8 VGND VPB 0.00613f
C9 a_27_297# Y 0.15327f
C10 VPB VPWR 0.05387f
C11 VGND B 0.03201f
C12 B VPWR 0.01761f
C13 VPB B 0.05665f
C14 A VGND 0.06336f
C15 A VPWR 0.04183f
C16 a_27_297# VGND 0.00726f
C17 a_27_297# VPWR 0.32192f
C18 A VPB 0.05627f
C19 a_27_297# VPB 0.0265f
C20 VGND Y 0.28934f
C21 VGND VNB 0.33964f
C22 Y VNB 0.06407f
C23 VPWR VNB 0.24456f
C24 B VNB 0.13115f
C25 A VNB 0.14015f
C26 VPB VNB 0.51617f
C27 a_27_297# VNB 0.05847f
.ends

.subckt BNE_4bit Q y1 x3/Y x8/B x2/Y x8/A x7/a_113_47# x3/a_113_47# x4/a_285_47# y0
+ x3/A a3 a2 a0 a1 x5/a_113_47# VDD x4/a_114_47# x8/a_27_297# GND x4/a_27_297#
Xx1 a0 GND GND VDD VDD x3/A sky130_fd_sc_hd__inv_1
Xx2 a3 GND GND VDD VDD x2/Y sky130_fd_sc_hd__inv_1
Xx3 x3/A a1 GND GND VDD VDD x3/Y x3/a_113_47# sky130_fd_sc_hd__nand2_1
Xx4 x3/Y a2 x2/Y GND GND VDD VDD y0 x4/a_114_47# x4/a_27_297# x4/a_285_47# sky130_fd_sc_hd__a21oi_2
Xx5 a2 a3 GND GND VDD VDD x8/B x5/a_113_47# sky130_fd_sc_hd__nand2_1
Xx6 x8/B GND GND VDD VDD y1 sky130_fd_sc_hd__inv_2
Xx7 a0 a1 GND GND VDD VDD x8/A x7/a_113_47# sky130_fd_sc_hd__nand2_1
Xx8 x8/A x8/B GND GND VDD VDD Q x8/a_27_297# sky130_fd_sc_hd__nor2_2
C0 a3 VDD 0.06962f
C1 x3/Y x4/a_114_47# 0.00277f
C2 a2 x8/A 0.04409f
C3 x4/a_285_47# y1 0
C4 a2 y1 0.0027f
C5 x4/a_27_297# a0 0
C6 x5/a_113_47# a0 0
C7 x2/Y VDD 0.58242f
C8 y0 a2 0.46137f
C9 x3/Y x8/A -0
C10 x3/Y y1 0
C11 x8/B a0 0.00237f
C12 a1 x4/a_285_47# 0.00247f
C13 a1 a2 0.01114f
C14 x3/Y y0 0.01643f
C15 a2 x8/a_27_297# 0
C16 x4/a_285_47# a3 0
C17 a0 Q 0
C18 a3 a2 0.94476f
C19 a1 x3/Y 0.31998f
C20 x4/a_114_47# a0 0.00119f
C21 x4/a_285_47# x2/Y 0
C22 x2/Y a2 0.15438f
C23 x3/Y a3 0.02862f
C24 y0 x3/A 0
C25 x8/A a0 0.18447f
C26 x3/Y x2/Y 0.12715f
C27 a1 x3/A 0.16832f
C28 x8/B x4/a_27_297# 0
C29 y1 a0 0.0016f
C30 x4/a_285_47# VDD -0
C31 a2 VDD 0.14542f
C32 y0 a0 0.01216f
C33 x7/a_113_47# x8/A 0
C34 a3 x3/A 0.08991f
C35 x7/a_113_47# y1 0
C36 a1 a0 0.18498f
C37 x3/Y VDD -0.00713f
C38 x2/Y x3/A 0.20296f
C39 x8/B Q 0.04294f
C40 a1 x3/a_113_47# 0
C41 a3 a0 0.71412f
C42 a1 x7/a_113_47# 0
C43 x8/A x4/a_27_297# 0
C44 x5/a_113_47# x8/A 0
C45 x5/a_113_47# y1 0
C46 x3/a_113_47# a3 0
C47 x2/Y a0 0.01529f
C48 x7/a_113_47# a3 0
C49 x3/A VDD 0.21053f
C50 y0 x4/a_27_297# 0.02878f
C51 x8/B x8/A 0.24564f
C52 x8/B y1 0.08516f
C53 x3/Y x4/a_285_47# 0
C54 x3/Y a2 0.05693f
C55 a1 x4/a_27_297# 0
C56 a1 x5/a_113_47# 0
C57 x8/B y0 0.04276f
C58 x8/A Q 0.01491f
C59 VDD a0 0.03117f
C60 y1 Q 0.09545f
C61 a1 x8/B 0
C62 a3 x4/a_27_297# 0
C63 y0 Q 0.06868f
C64 x3/a_113_47# VDD -0
C65 x4/a_114_47# y1 0
C66 x7/a_113_47# VDD -0
C67 x8/B x8/a_27_297# 0.06527f
C68 a2 x3/A 0.06454f
C69 x2/Y x4/a_27_297# 0.10702f
C70 a3 x8/B 0.00632f
C71 a1 Q 0
C72 y1 x8/A 0.09461f
C73 Q x8/a_27_297# 0.00647f
C74 x2/Y x8/B 0
C75 x3/Y x3/A 0.08615f
C76 a1 x4/a_114_47# 0.00342f
C77 a3 Q 0
C78 y0 x8/A 0.02047f
C79 x4/a_285_47# a0 0
C80 a2 a0 0.00623f
C81 y0 y1 0.13123f
C82 x5/a_113_47# VDD -0
C83 VDD x4/a_27_297# 0.03494f
C84 a3 x4/a_114_47# 0
C85 x2/Y Q 0
C86 a1 x8/A 0.04526f
C87 a1 y1 0
C88 x3/Y a0 0.02245f
C89 x8/B VDD 0.31811f
C90 x8/A x8/a_27_297# 0.00308f
C91 x2/Y x4/a_114_47# 0
C92 a1 y0 0.06418f
C93 y1 x8/a_27_297# 0.00322f
C94 a3 x8/A 0.0763f
C95 a3 y1 0
C96 x3/Y x3/a_113_47# 0
C97 y0 x8/a_27_297# 0.01515f
C98 VDD Q 0.03744f
C99 a3 y0 0.00972f
C100 x2/Y x8/A 0.01779f
C101 x2/Y y1 0
C102 x3/A a0 0.02178f
C103 a2 x4/a_27_297# 0.02657f
C104 x5/a_113_47# a2 0
C105 x4/a_114_47# VDD -0.00124f
C106 a1 a3 0.07098f
C107 x2/Y y0 0.09784f
C108 x3/a_113_47# x3/A 0
C109 x8/B a2 0.10735f
C110 a1 x2/Y 0.21495f
C111 x3/Y x4/a_27_297# 0.00398f
C112 x8/A VDD 0.11942f
C113 y1 VDD 0.00362f
C114 x2/Y x8/a_27_297# 0
C115 a2 Q 0.00396f
C116 y0 VDD 0.16258f
C117 x2/Y a3 0.04076f
C118 x3/a_113_47# a0 0
C119 x7/a_113_47# a0 0
C120 a1 VDD 0.05352f
C121 x3/A x4/a_27_297# 0
C122 VDD x8/a_27_297# 0.08561f
C123 Q GND 0.02883f
C124 VDD GND -1.22121f
C125 x8/A GND 0.59054f
C126 x8/a_27_297# GND -0.00521f
C127 a0 GND 0.43707f
C128 a1 GND 1.23381f
C129 x7/a_113_47# GND 0
C130 y1 GND 0.14669f
C131 x8/B GND -0.02398f
C132 a2 GND 0.1675f
C133 a3 GND 0.02918f
C134 x5/a_113_47# GND -0
C135 y0 GND 0.25308f
C136 x2/Y GND -0.08856f
C137 x3/Y GND -0.01051f
C138 x4/a_285_47# GND -0.0012f
C139 x4/a_114_47# GND -0.00235f
C140 x4/a_27_297# GND -0.00813f
C141 x3/A GND -0.05745f
C142 x3/a_113_47# GND -0
.ends

.subckt sky130_fd_sc_hd__nor4_2 A B C D VGND VNB VPB VPWR Y a_475_297# a_281_297#
+ a_27_297#
X0 a_281_297# B a_27_297# VPB sky130_fd_pr__pfet_01v8_hvt ad=0.135 pd=1.27 as=0.135 ps=1.27 w=1 l=0.15
X1 Y B VGND VNB sky130_fd_pr__nfet_01v8 ad=0.08775 pd=0.92 as=0.08775 ps=0.92 w=0.65 l=0.15
X2 a_27_297# A VPWR VPB sky130_fd_pr__pfet_01v8_hvt ad=0.135 pd=1.27 as=0.135 ps=1.27 w=1 l=0.15
X3 a_475_297# D Y VPB sky130_fd_pr__pfet_01v8_hvt ad=0.26 pd=2.52 as=0.135 ps=1.27 w=1 l=0.15
X4 VGND C Y VNB sky130_fd_pr__nfet_01v8 ad=0.08775 pd=0.92 as=0.08775 ps=0.92 w=0.65 l=0.15
X5 Y D a_475_297# VPB sky130_fd_pr__pfet_01v8_hvt ad=0.135 pd=1.27 as=0.135 ps=1.27 w=1 l=0.15
X6 VGND D Y VNB sky130_fd_pr__nfet_01v8 ad=0.169 pd=1.82 as=0.08775 ps=0.92 w=0.65 l=0.15
X7 VGND A Y VNB sky130_fd_pr__nfet_01v8 ad=0.08775 pd=0.92 as=0.08775 ps=0.92 w=0.65 l=0.15
X8 Y A VGND VNB sky130_fd_pr__nfet_01v8 ad=0.08775 pd=0.92 as=0.182 ps=1.86 w=0.65 l=0.15
X9 VGND B Y VNB sky130_fd_pr__nfet_01v8 ad=0.182 pd=1.86 as=0.08775 ps=0.92 w=0.65 l=0.15
X10 Y D VGND VNB sky130_fd_pr__nfet_01v8 ad=0.08775 pd=0.92 as=0.08775 ps=0.92 w=0.65 l=0.15
X11 VPWR A a_27_297# VPB sky130_fd_pr__pfet_01v8_hvt ad=0.135 pd=1.27 as=0.28 ps=2.56 w=1 l=0.15
X12 a_475_297# C a_281_297# VPB sky130_fd_pr__pfet_01v8_hvt ad=0.135 pd=1.27 as=0.135 ps=1.27 w=1 l=0.15
X13 a_281_297# C a_475_297# VPB sky130_fd_pr__pfet_01v8_hvt ad=0.135 pd=1.27 as=0.28 ps=2.56 w=1 l=0.15
X14 a_27_297# B a_281_297# VPB sky130_fd_pr__pfet_01v8_hvt ad=0.28 pd=2.56 as=0.135 ps=1.27 w=1 l=0.15
X15 Y C VGND VNB sky130_fd_pr__nfet_01v8 ad=0.08775 pd=0.92 as=0.182 ps=1.86 w=0.65 l=0.15
C0 a_27_297# VPB 0.01637f
C1 B a_475_297# 0
C2 a_281_297# a_475_297# 0.14254f
C3 Y B 0.09805f
C4 C a_475_297# 0.09485f
C5 a_281_297# Y 0.00208f
C6 C Y 0.10844f
C7 D C 0.06752f
C8 a_27_297# VGND 0.00869f
C9 VPWR a_475_297# 0.1392f
C10 a_27_297# A 0.10136f
C11 VPB a_475_297# 0.01473f
C12 Y VPWR 0.02028f
C13 a_281_297# B 0.02077f
C14 C B 0.03113f
C15 VPB Y 0.01667f
C16 D VPWR 0.01721f
C17 D VPB 0.05679f
C18 a_281_297# C 0.02487f
C19 B VPWR 0.02267f
C20 VGND a_475_297# 0.00567f
C21 VPB B 0.05766f
C22 a_281_297# VPWR 0.18503f
C23 C VPWR 0.02221f
C24 Y VGND 0.61093f
C25 a_281_297# VPB 0.01178f
C26 VPB C 0.06048f
C27 D VGND 0.03204f
C28 Y A 0.06144f
C29 B VGND 0.03283f
C30 VPB VPWR 0.10274f
C31 a_281_297# VGND 0.00327f
C32 C VGND 0.03351f
C33 B A 0.06913f
C34 a_27_297# a_475_297# 0.03869f
C35 a_27_297# Y 0.01188f
C36 VPWR VGND 0.09016f
C37 VPB VGND 0.0115f
C38 VPWR A 0.04358f
C39 VPB A 0.05602f
C40 a_27_297# B 0.10037f
C41 a_27_297# a_281_297# 0.14254f
C42 a_27_297# C 0
C43 Y a_475_297# 0.14973f
C44 D a_475_297# 0.04753f
C45 D Y 0.15452f
C46 A VGND 0.05439f
C47 a_27_297# VPWR 0.22859f
C48 VGND VNB 0.56962f
C49 Y VNB 0.0798f
C50 VPWR VNB 0.4303f
C51 D VNB 0.13001f
C52 C VNB 0.11765f
C53 B VNB 0.1154f
C54 A VNB 0.14f
C55 VPB VNB 0.95915f
C56 a_475_297# VNB 0.0225f
C57 a_281_297# VNB 0
C58 a_27_297# VNB 0.03729f
.ends

.subckt sky130_fd_sc_hd__nor2_1 A B VGND VNB VPB VPWR Y a_109_297#
X0 VPWR A a_109_297# VPB sky130_fd_pr__pfet_01v8_hvt ad=0.26 pd=2.52 as=0.105 ps=1.21 w=1 l=0.15
X1 VGND A Y VNB sky130_fd_pr__nfet_01v8 ad=0.169 pd=1.82 as=0.08775 ps=0.92 w=0.65 l=0.15
X2 a_109_297# B Y VPB sky130_fd_pr__pfet_01v8_hvt ad=0.105 pd=1.21 as=0.26 ps=2.52 w=1 l=0.15
X3 Y B VGND VNB sky130_fd_pr__nfet_01v8 ad=0.08775 pd=0.92 as=0.169 ps=1.82 w=0.65 l=0.15
C0 VPWR VPB 0.0536f
C1 Y B 0.08765f
C2 VPWR a_109_297# 0.01162f
C3 VPWR VGND 0.03144f
C4 A B 0.05841f
C5 VPB B 0.0367f
C6 VGND B 0.04768f
C7 A Y 0.04707f
C8 VPWR B 0.0166f
C9 VPB Y 0.01392f
C10 a_109_297# Y 0.01129f
C11 VGND Y 0.15455f
C12 VPWR Y 0.09969f
C13 A VPB 0.04146f
C14 A VGND 0.05098f
C15 VPWR A 0.05789f
C16 VPB VGND 0.00456f
C17 a_109_297# VGND 0.00128f
C18 VGND VNB 0.26093f
C19 VPWR VNB 0.2048f
C20 Y VNB 0.06051f
C21 A VNB 0.11585f
C22 B VNB 0.10959f
C23 VPB VNB 0.33898f
.ends

.subckt sky130_fd_sc_hd__a21oi_1 A1 A2 B1 VGND VNB VPB VPWR Y a_199_47# a_113_297#
X0 a_199_47# A1 Y VNB sky130_fd_pr__nfet_01v8 ad=0.09588 pd=0.945 as=0.091 ps=0.93 w=0.65 l=0.15
X1 a_113_297# A2 VPWR VPB sky130_fd_pr__pfet_01v8_hvt ad=0.265 pd=2.53 as=0.1475 ps=1.295 w=1 l=0.15
X2 Y B1 VGND VNB sky130_fd_pr__nfet_01v8 ad=0.091 pd=0.93 as=0.17225 ps=1.83 w=0.65 l=0.15
X3 VPWR A1 a_113_297# VPB sky130_fd_pr__pfet_01v8_hvt ad=0.1475 pd=1.295 as=0.14 ps=1.28 w=1 l=0.15
X4 a_113_297# B1 Y VPB sky130_fd_pr__pfet_01v8_hvt ad=0.14 pd=1.28 as=0.265 ps=2.53 w=1 l=0.15
X5 VGND A2 a_199_47# VNB sky130_fd_pr__nfet_01v8 ad=0.17225 pd=1.83 as=0.09588 ps=0.945 w=0.65 l=0.15
C0 A1 Y 0.08125f
C1 B1 a_113_297# 0.00758f
C2 B1 VPB 0.03887f
C3 a_113_297# VGND 0.00882f
C4 VPWR B1 0.01343f
C5 a_199_47# VGND 0.00498f
C6 VPB VGND 0.00548f
C7 VPWR VGND 0.03696f
C8 A2 VGND 0.04948f
C9 B1 Y 0.1126f
C10 a_113_297# a_199_47# 0
C11 a_113_297# VPB 0.0108f
C12 VPWR a_113_297# 0.17761f
C13 Y VGND 0.06556f
C14 A2 a_113_297# 0.04762f
C15 VPWR a_199_47# 0
C16 VPWR VPB 0.04551f
C17 A2 VPB 0.03728f
C18 A2 VPWR 0.0147f
C19 a_113_297# Y 0.09093f
C20 B1 A1 0.05184f
C21 Y a_199_47# 0.00151f
C22 Y VPB 0.01464f
C23 A1 VGND 0.07796f
C24 VPWR Y 0.0448f
C25 A2 Y 0.00122f
C26 A1 a_113_297# 0.05001f
C27 A1 a_199_47# 0.00917f
C28 A1 VPB 0.02639f
C29 VPWR A1 0.01539f
C30 A2 A1 0.09123f
C31 B1 VGND 0.0436f
C32 VGND VNB 0.28505f
C33 VPWR VNB 0.20747f
C34 Y VNB 0.05443f
C35 A2 VNB 0.11067f
C36 A1 VNB 0.06492f
C37 B1 VNB 0.12884f
C38 VPB VNB 0.42757f
C39 a_113_297# VNB 0.034f
.ends

.subckt NLC_4bit X2 Z1 a Z0 x1/a_27_297# x2/a_109_297# X0 X1 x4/Y x3/a_113_297# X3
+ x3/a_199_47# x1/a_475_297# x1/a_281_297# VDD GND
Xx1 X3 X2 X1 X0 GND GND VDD VDD a x1/a_475_297# x1/a_281_297# x1/a_27_297# sky130_fd_sc_hd__nor4_2
Xx2 X3 X2 GND GND VDD VDD Z1 x2/a_109_297# sky130_fd_sc_hd__nor2_1
Xx3 x4/Y X1 X3 GND GND VDD VDD Z0 x3/a_199_47# x3/a_113_297# sky130_fd_sc_hd__a21oi_1
Xx4 X2 GND GND VDD VDD x4/Y sky130_fd_sc_hd__inv_1
C0 Z1 X0 0.06386f
C1 x3/a_199_47# VDD -0
C2 X2 a 0.00447f
C3 Z1 VDD 0.86121f
C4 X2 x2/a_109_297# 0
C5 a x4/Y 0.07659f
C6 x2/a_109_297# x4/Y 0
C7 x1/a_27_297# X3 0.00657f
C8 Z0 X3 0.04106f
C9 X2 x1/a_27_297# 0.00774f
C10 X1 a 0.09565f
C11 X2 Z0 0
C12 x2/a_109_297# X1 0.00217f
C13 x3/a_113_297# a 0.00611f
C14 Z0 x4/Y 0.15684f
C15 x1/a_475_297# X0 0.01484f
C16 x1/a_475_297# VDD -0.01534f
C17 x1/a_27_297# X1 0.07604f
C18 X1 Z0 0.14273f
C19 Z0 x3/a_113_297# 0.00161f
C20 X3 X0 0.1354f
C21 VDD X3 0.01076f
C22 X2 X0 0.20052f
C23 X2 VDD 0.01453f
C24 Z1 x1/a_475_297# 0.06488f
C25 x4/Y X0 0.00971f
C26 VDD x4/Y 0.00166f
C27 Z0 a 0.09965f
C28 X1 X0 0.14623f
C29 x1/a_281_297# X0 0.01243f
C30 X1 VDD 0.18019f
C31 x3/a_113_297# X0 0.00223f
C32 VDD x1/a_281_297# -0.01076f
C33 x3/a_199_47# X3 0
C34 Z1 X3 0.03001f
C35 x3/a_113_297# VDD 0.0264f
C36 X2 Z1 0.02685f
C37 x3/a_199_47# x4/Y 0.00132f
C38 Z1 x4/Y 0.06011f
C39 a X0 0.04962f
C40 Z1 X1 0.61135f
C41 x2/a_109_297# X0 0.00154f
C42 Z1 x1/a_281_297# 0.06065f
C43 a VDD 0.00621f
C44 Z1 x3/a_113_297# 0.07179f
C45 x2/a_109_297# VDD -0.00191f
C46 x1/a_475_297# X3 0.00497f
C47 x1/a_27_297# X0 0.01328f
C48 Z0 X0 0.00271f
C49 x1/a_27_297# VDD 0.01649f
C50 x1/a_475_297# x4/Y 0
C51 Z0 VDD 0.00483f
C52 x3/a_199_47# a 0
C53 X1 x1/a_475_297# 0.05782f
C54 Z1 a 0.06804f
C55 Z1 x2/a_109_297# 0.00406f
C56 X2 X3 0.55732f
C57 x3/a_113_297# x1/a_475_297# 0
C58 x4/Y X3 0.73566f
C59 X2 x4/Y 0.0885f
C60 Z1 x1/a_27_297# 0.05413f
C61 x3/a_199_47# Z0 0.00103f
C62 Z1 Z0 0.02553f
C63 X1 X3 0.32338f
C64 x1/a_281_297# X3 0
C65 VDD X0 0.1255f
C66 X2 X1 0.21003f
C67 X2 x1/a_281_297# 0.00112f
C68 a x1/a_475_297# 0
C69 X1 x4/Y 0.12462f
C70 x3/a_113_297# x4/Y 0
C71 X1 x1/a_281_297# 0.01449f
C72 X1 x3/a_113_297# 0.04798f
C73 Z0 x1/a_475_297# 0.01966f
C74 a X3 0.31287f
C75 x4/Y GND 1.12578f
C76 VDD GND -0.56651f
C77 X2 GND 0.02174f
C78 Z0 GND 0.1172f
C79 X1 GND 0.0536f
C80 X3 GND 0.3543f
C81 x3/a_199_47# GND -0
C82 x3/a_113_297# GND -0.00535f
C83 Z1 GND -0.00912f
C84 x2/a_109_297# GND -0.00128f
C85 a GND 0.01204f
C86 X0 GND 0.20756f
C87 x1/a_475_297# GND -0.00567f
C88 x1/a_281_297# GND -0.00327f
C89 x1/a_27_297# GND -0.00664f
.ends

.subckt ZLC_16bit Y4 Y0 Y2 Y3 A9 A8 A10 A11 A15 A14 A13 A12 A7 A6 A5 A4 A3 A2 A1 A0
+ GND Y1 VDD
Xsky130_fd_sc_hd__inv_1_4 sky130_fd_sc_hd__inv_1_4/A GND GND VDD VDD Y0 sky130_fd_sc_hd__inv_1
XZMUX4_0 ZMUX4_0/Z3_1 ZMUX4_0/Z2_1 ZMUX4_0/Z1_1 ZMUX4_0/Z0_1 ZMUX4_0/y1 ZMUX4_0/y0
+ ZMUX4_0/Z3_0 ZMUX4_0/Z2_0 ZMUX4_0/Z1_0 ZMUX4_0/Z0_0 ZMUX4_0/Zo_1 ZMUX4_0/Zo_0 ZMUX4_0/sky130_fd_sc_hd__mux4_1_1/a_757_363#
+ ZMUX4_0/sky130_fd_sc_hd__mux4_1_0/a_834_97# ZMUX4_0/sky130_fd_sc_hd__mux4_1_0/a_27_47#
+ ZMUX4_0/sky130_fd_sc_hd__mux4_1_0/a_247_21# ZMUX4_0/sky130_fd_sc_hd__mux4_1_0/a_668_97#
+ ZMUX4_0/sky130_fd_sc_hd__mux4_1_0/a_923_363# ZMUX4_0/sky130_fd_sc_hd__mux4_1_0/a_277_47#
+ ZMUX4_0/sky130_fd_sc_hd__mux4_1_1/a_834_97# ZMUX4_0/sky130_fd_sc_hd__mux4_1_1/a_923_363#
+ ZMUX4_0/sky130_fd_sc_hd__mux4_1_0/a_1290_413# ZMUX4_0/sky130_fd_sc_hd__mux4_1_1/a_1290_413#
+ ZMUX4_0/sky130_fd_sc_hd__mux4_1_1/a_247_21# ZMUX4_0/sky130_fd_sc_hd__mux4_1_1/a_27_47#
+ ZMUX4_0/sky130_fd_sc_hd__mux4_1_0/a_1478_413# ZMUX4_0/sky130_fd_sc_hd__mux4_1_1/a_668_97#
+ ZMUX4_0/sky130_fd_sc_hd__mux4_1_0/a_750_97# ZMUX4_0/sky130_fd_sc_hd__mux4_1_0/a_27_413#
+ ZMUX4_0/sky130_fd_sc_hd__mux4_1_1/a_1478_413# ZMUX4_0/sky130_fd_sc_hd__mux4_1_1/a_277_47#
+ ZMUX4_0/sky130_fd_sc_hd__mux4_1_0/a_193_47# ZMUX4_0/sky130_fd_sc_hd__mux4_1_1/a_750_97#
+ ZMUX4_0/sky130_fd_sc_hd__mux4_1_1/a_27_413# VDD ZMUX4_0/sky130_fd_sc_hd__mux4_1_0/a_193_413#
+ ZMUX4_0/sky130_fd_sc_hd__mux4_1_1/a_193_47# ZMUX4_0/sky130_fd_sc_hd__mux4_1_0/a_757_363#
+ ZMUX4_0/sky130_fd_sc_hd__mux4_1_1/a_193_413# GND ZMUX4
XBNE_4bit_0 Y4 ZMUX4_0/y1 BNE_4bit_0/x3/Y BNE_4bit_0/x8/B BNE_4bit_0/x2/Y BNE_4bit_0/x8/A
+ BNE_4bit_0/x7/a_113_47# BNE_4bit_0/x3/a_113_47# BNE_4bit_0/x4/a_285_47# ZMUX4_0/y0
+ BNE_4bit_0/x3/A NLC_4bit_3/a NLC_4bit_2/a NLC_4bit_0/a NLC_4bit_1/a BNE_4bit_0/x5/a_113_47#
+ VDD BNE_4bit_0/x4/a_114_47# BNE_4bit_0/x8/a_27_297# GND BNE_4bit_0/x4/a_27_297#
+ BNE_4bit
Xsky130_fd_sc_hd__nand2_1_0 sky130_fd_sc_hd__inv_1_1/Y ZMUX4_0/y1 GND GND VDD VDD
+ sky130_fd_sc_hd__inv_1_0/A sky130_fd_sc_hd__nand2_1_0/a_113_47# sky130_fd_sc_hd__nand2_1
Xsky130_fd_sc_hd__nand2_1_1 sky130_fd_sc_hd__inv_1_1/Y ZMUX4_0/y0 GND GND VDD VDD
+ sky130_fd_sc_hd__inv_1_2/A sky130_fd_sc_hd__nand2_1_1/a_113_47# sky130_fd_sc_hd__nand2_1
Xsky130_fd_sc_hd__nand2_1_2 sky130_fd_sc_hd__inv_1_1/Y ZMUX4_0/Zo_1 GND GND VDD VDD
+ sky130_fd_sc_hd__inv_1_3/A sky130_fd_sc_hd__nand2_1_2/a_113_47# sky130_fd_sc_hd__nand2_1
Xsky130_fd_sc_hd__nand2_1_3 sky130_fd_sc_hd__inv_1_1/Y ZMUX4_0/Zo_0 GND GND VDD VDD
+ sky130_fd_sc_hd__inv_1_4/A sky130_fd_sc_hd__nand2_1_3/a_113_47# sky130_fd_sc_hd__nand2_1
XNLC_4bit_0 A2 ZMUX4_0/Z0_1 NLC_4bit_0/a ZMUX4_0/Z0_0 NLC_4bit_0/x1/a_27_297# NLC_4bit_0/x2/a_109_297#
+ A0 A1 NLC_4bit_0/x4/Y NLC_4bit_0/x3/a_113_297# A3 NLC_4bit_0/x3/a_199_47# NLC_4bit_0/x1/a_475_297#
+ NLC_4bit_0/x1/a_281_297# VDD GND NLC_4bit
XNLC_4bit_1 A6 ZMUX4_0/Z1_1 NLC_4bit_1/a ZMUX4_0/Z1_0 NLC_4bit_1/x1/a_27_297# NLC_4bit_1/x2/a_109_297#
+ A4 A5 NLC_4bit_1/x4/Y NLC_4bit_1/x3/a_113_297# A7 NLC_4bit_1/x3/a_199_47# NLC_4bit_1/x1/a_475_297#
+ NLC_4bit_1/x1/a_281_297# VDD GND NLC_4bit
Xsky130_fd_sc_hd__inv_1_1 Y4 GND GND VDD VDD sky130_fd_sc_hd__inv_1_1/Y sky130_fd_sc_hd__inv_1
Xsky130_fd_sc_hd__inv_1_0 sky130_fd_sc_hd__inv_1_0/A GND GND VDD VDD Y3 sky130_fd_sc_hd__inv_1
XNLC_4bit_2 A10 ZMUX4_0/Z2_1 NLC_4bit_2/a ZMUX4_0/Z2_0 NLC_4bit_2/x1/a_27_297# NLC_4bit_2/x2/a_109_297#
+ A8 A9 NLC_4bit_2/x4/Y NLC_4bit_2/x3/a_113_297# A11 NLC_4bit_2/x3/a_199_47# NLC_4bit_2/x1/a_475_297#
+ NLC_4bit_2/x1/a_281_297# VDD GND NLC_4bit
Xsky130_fd_sc_hd__inv_1_2 sky130_fd_sc_hd__inv_1_2/A GND GND VDD VDD Y2 sky130_fd_sc_hd__inv_1
XNLC_4bit_3 A14 ZMUX4_0/Z3_1 NLC_4bit_3/a ZMUX4_0/Z3_0 NLC_4bit_3/x1/a_27_297# NLC_4bit_3/x2/a_109_297#
+ A12 A13 NLC_4bit_3/x4/Y NLC_4bit_3/x3/a_113_297# A15 NLC_4bit_3/x3/a_199_47# NLC_4bit_3/x1/a_475_297#
+ NLC_4bit_3/x1/a_281_297# VDD GND NLC_4bit
Xsky130_fd_sc_hd__inv_1_3 sky130_fd_sc_hd__inv_1_3/A GND GND VDD VDD Y1 sky130_fd_sc_hd__inv_1
C0 ZMUX4_0/sky130_fd_sc_hd__mux4_1_1/a_923_363# ZMUX4_0/Z1_1 0
C1 A8 VDD 0.05056f
C2 NLC_4bit_1/x4/Y BNE_4bit_0/x3/A 0
C3 A12 ZMUX4_0/sky130_fd_sc_hd__mux4_1_0/a_27_413# 0
C4 ZMUX4_0/sky130_fd_sc_hd__mux4_1_0/a_750_97# ZMUX4_0/Z0_1 0.01758f
C5 ZMUX4_0/sky130_fd_sc_hd__mux4_1_0/a_750_97# ZMUX4_0/sky130_fd_sc_hd__mux4_1_0/a_1478_413# -0
C6 ZMUX4_0/Z2_0 ZMUX4_0/Z3_0 0.04229f
C7 ZMUX4_0/Z3_1 ZMUX4_0/Z3_0 0.01085f
C8 NLC_4bit_1/a BNE_4bit_0/x3/a_113_47# 0
C9 NLC_4bit_0/a BNE_4bit_0/x7/a_113_47# 0
C10 ZMUX4_0/Zo_1 ZMUX4_0/sky130_fd_sc_hd__mux4_1_1/a_1478_413# 0.00145f
C11 A3 ZMUX4_0/Z1_1 0
C12 sky130_fd_sc_hd__nand2_1_1/a_113_47# VDD -0
C13 sky130_fd_sc_hd__nand2_1_1/a_113_47# ZMUX4_0/Z0_0 0
C14 NLC_4bit_0/a NLC_4bit_1/x3/a_113_297# 0
C15 A3 A7 0.15991f
C16 ZMUX4_0/Z2_1 ZMUX4_0/sky130_fd_sc_hd__mux4_1_1/a_750_97# 0.00138f
C17 ZMUX4_0/sky130_fd_sc_hd__mux4_1_0/a_247_21# ZMUX4_0/Z0_1 0.01173f
C18 NLC_4bit_2/a Y4 0
C19 A13 A4 0
C20 ZMUX4_0/Z1_0 ZMUX4_0/sky130_fd_sc_hd__mux4_1_0/a_277_47# 0.00335f
C21 BNE_4bit_0/x3/A ZMUX4_0/Z1_1 0
C22 ZMUX4_0/sky130_fd_sc_hd__mux4_1_0/a_27_47# ZMUX4_0/Z3_0 0.00976f
C23 ZMUX4_0/Z0_1 NLC_4bit_0/x3/a_113_297# 0
C24 NLC_4bit_0/a NLC_4bit_2/x4/Y 0
C25 NLC_4bit_3/a ZMUX4_0/sky130_fd_sc_hd__mux4_1_1/a_27_413# 0.00655f
C26 NLC_4bit_1/x4/Y NLC_4bit_1/a 0.01705f
C27 ZMUX4_0/y1 ZMUX4_0/sky130_fd_sc_hd__mux4_1_1/a_757_363# 0.00205f
C28 Y1 ZMUX4_0/Z0_1 0.00667f
C29 ZMUX4_0/y1 A5 0.03469f
C30 BNE_4bit_0/x3/A A7 0
C31 NLC_4bit_2/x1/a_281_297# A4 0.00158f
C32 NLC_4bit_2/a ZMUX4_0/Z3_1 0
C33 ZMUX4_0/Z2_0 NLC_4bit_2/a 0.01662f
C34 A3 BNE_4bit_0/x2/Y 0.00171f
C35 NLC_4bit_3/a ZMUX4_0/sky130_fd_sc_hd__mux4_1_1/a_247_21# 0
C36 A3 BNE_4bit_0/x4/a_27_297# 0
C37 ZMUX4_0/Z1_0 ZMUX4_0/Zo_0 0.27531f
C38 A12 ZMUX4_0/Z3_0 0
C39 BNE_4bit_0/x8/a_27_297# ZMUX4_0/sky130_fd_sc_hd__mux4_1_1/a_247_21# 0
C40 sky130_fd_sc_hd__inv_1_1/Y ZMUX4_0/Zo_0 0.11281f
C41 NLC_4bit_1/a ZMUX4_0/Z1_1 0.01274f
C42 ZMUX4_0/Z2_1 A8 0
C43 ZMUX4_0/sky130_fd_sc_hd__mux4_1_1/a_277_47# ZMUX4_0/Z0_1 0.01184f
C44 ZMUX4_0/sky130_fd_sc_hd__mux4_1_0/a_757_363# VDD -0
C45 NLC_4bit_2/a ZMUX4_0/sky130_fd_sc_hd__mux4_1_0/a_27_47# 0
C46 ZMUX4_0/sky130_fd_sc_hd__mux4_1_0/a_757_363# ZMUX4_0/Z0_0 0
C47 NLC_4bit_1/a A7 0.11882f
C48 ZMUX4_0/sky130_fd_sc_hd__mux4_1_1/a_750_97# BNE_4bit_0/x8/B 0
C49 A8 NLC_4bit_1/x1/a_281_297# 0.00145f
C50 ZMUX4_0/Z1_1 NLC_4bit_3/x4/Y 0.00808f
C51 ZMUX4_0/y0 ZMUX4_0/sky130_fd_sc_hd__mux4_1_0/a_277_47# -0
C52 NLC_4bit_0/a BNE_4bit_0/x3/a_113_47# 0
C53 ZMUX4_0/Z3_1 A6 0
C54 A9 A5 0.01461f
C55 ZMUX4_0/Z3_0 ZMUX4_0/sky130_fd_sc_hd__mux4_1_0/a_27_413# 0.00142f
C56 A7 NLC_4bit_3/x4/Y 0
C57 ZMUX4_0/sky130_fd_sc_hd__mux4_1_1/a_247_21# ZMUX4_0/sky130_fd_sc_hd__mux4_1_1/a_1290_413# -0
C58 NLC_4bit_3/x1/a_27_297# VDD -0
C59 ZMUX4_0/Z0_1 VDD 0.27975f
C60 ZMUX4_0/Z1_0 Y4 0
C61 NLC_4bit_3/a NLC_4bit_2/x4/Y 0.00246f
C62 ZMUX4_0/Zo_1 ZMUX4_0/Z1_1 0.13166f
C63 ZMUX4_0/sky130_fd_sc_hd__mux4_1_0/a_1478_413# VDD -0.01078f
C64 NLC_4bit_1/x1/a_475_297# NLC_4bit_1/a 0.00498f
C65 ZMUX4_0/Z0_1 ZMUX4_0/Z0_0 0.152f
C66 ZMUX4_0/y1 sky130_fd_sc_hd__inv_1_0/A 0.05612f
C67 A12 NLC_4bit_2/a 0
C68 sky130_fd_sc_hd__inv_1_1/Y Y4 0.05838f
C69 Y0 ZMUX4_0/Zo_0 0
C70 NLC_4bit_1/x4/Y NLC_4bit_0/a 0.00195f
C71 NLC_4bit_1/a NLC_4bit_2/x1/a_475_297# 0.00342f
C72 NLC_4bit_1/a BNE_4bit_0/x2/Y 0.01656f
C73 BNE_4bit_0/x4/a_27_297# NLC_4bit_1/a 0.00174f
C74 ZMUX4_0/y0 ZMUX4_0/Zo_0 -0
C75 ZMUX4_0/Zo_1 Y3 0
C76 sky130_fd_sc_hd__nand2_1_1/a_113_47# sky130_fd_sc_hd__inv_1_2/A 0
C77 ZMUX4_0/sky130_fd_sc_hd__mux4_1_0/a_750_97# ZMUX4_0/sky130_fd_sc_hd__mux4_1_0/a_277_47# -0.01285f
C78 Y2 ZMUX4_0/Z0_1 0.02549f
C79 sky130_fd_sc_hd__nand2_1_0/a_113_47# ZMUX4_0/Z0_1 0
C80 ZMUX4_0/Z1_0 ZMUX4_0/Z3_1 0
C81 ZMUX4_0/Z2_0 ZMUX4_0/Z1_0 0
C82 sky130_fd_sc_hd__inv_1_1/Y ZMUX4_0/Z3_1 0
C83 ZMUX4_0/Z2_0 NLC_4bit_2/x1/a_27_297# 0
C84 A1 A5 0.01563f
C85 A3 BNE_4bit_0/x3/Y 0
C86 A5 sky130_fd_sc_hd__inv_1_0/A 0.0014f
C87 A1 A9 0
C88 A12 A6 0
C89 ZMUX4_0/sky130_fd_sc_hd__mux4_1_0/a_247_21# ZMUX4_0/sky130_fd_sc_hd__mux4_1_0/a_277_47# -0
C90 ZMUX4_0/Z1_0 ZMUX4_0/sky130_fd_sc_hd__mux4_1_0/a_27_47# 0
C91 NLC_4bit_0/a ZMUX4_0/Z1_1 0
C92 ZMUX4_0/Z3_1 NLC_4bit_3/x1/a_475_297# 0
C93 ZMUX4_0/sky130_fd_sc_hd__mux4_1_1/a_834_97# ZMUX4_0/Z1_1 0
C94 ZMUX4_0/sky130_fd_sc_hd__mux4_1_0/a_750_97# ZMUX4_0/Zo_0 0
C95 A4 NLC_4bit_1/x1/a_27_297# -0
C96 sky130_fd_sc_hd__inv_1_1/Y ZMUX4_0/sky130_fd_sc_hd__mux4_1_0/a_27_47# 0
C97 NLC_4bit_0/x1/a_475_297# BNE_4bit_0/x2/Y 0
C98 ZMUX4_0/sky130_fd_sc_hd__mux4_1_0/a_668_97# ZMUX4_0/y0 0
C99 ZMUX4_0/y0 Y4 0.00134f
C100 A7 NLC_4bit_0/a 0.00338f
C101 A11 ZMUX4_0/Z3_1 0
C102 ZMUX4_0/Z2_0 A11 0
C103 NLC_4bit_2/x2/a_109_297# ZMUX4_0/Z1_1 0
C104 ZMUX4_0/sky130_fd_sc_hd__mux4_1_1/a_1478_413# ZMUX4_0/sky130_fd_sc_hd__mux4_1_1/a_1290_413# -0.00167f
C105 Y3 NLC_4bit_0/a 0
C106 sky130_fd_sc_hd__inv_1_4/A ZMUX4_0/Z1_0 0.15634f
C107 A3 A10 0
C108 sky130_fd_sc_hd__inv_1_1/Y sky130_fd_sc_hd__inv_1_4/A 0.27359f
C109 ZMUX4_0/Z2_1 NLC_4bit_3/x1/a_27_297# 0
C110 ZMUX4_0/Z2_1 ZMUX4_0/Z0_1 0.00218f
C111 ZMUX4_0/Z2_1 ZMUX4_0/sky130_fd_sc_hd__mux4_1_0/a_1478_413# 0
C112 NLC_4bit_1/x4/Y NLC_4bit_3/a 0
C113 NLC_4bit_3/a ZMUX4_0/sky130_fd_sc_hd__mux4_1_1/a_193_47# 0
C114 ZMUX4_0/Z2_0 ZMUX4_0/y0 -0
C115 ZMUX4_0/Z3_1 ZMUX4_0/y0 0.01412f
C116 A4 NLC_4bit_1/x2/a_109_297# -0
C117 BNE_4bit_0/x8/A NLC_4bit_1/a 0
C118 Y1 ZMUX4_0/Zo_0 0
C119 BNE_4bit_0/x2/Y NLC_4bit_0/a 0.00893f
C120 BNE_4bit_0/x4/a_27_297# NLC_4bit_0/a 0.00885f
C121 A1 sky130_fd_sc_hd__inv_1_0/A 0.01345f
C122 BNE_4bit_0/x3/A A10 0
C123 ZMUX4_0/Z0_1 ZMUX4_0/sky130_fd_sc_hd__mux4_1_1/a_27_47# 0
C124 NLC_4bit_1/a BNE_4bit_0/x3/Y 0.0206f
C125 NLC_4bit_2/x3/a_113_297# ZMUX4_0/Z0_1 0
C126 ZMUX4_0/Z0_1 sky130_fd_sc_hd__inv_1_2/A 0.04902f
C127 NLC_4bit_2/a ZMUX4_0/Z3_0 0.00665f
C128 ZMUX4_0/sky130_fd_sc_hd__mux4_1_0/a_27_47# ZMUX4_0/y0 -0.00127f
C129 NLC_4bit_3/a ZMUX4_0/Z1_1 0.05545f
C130 A11 A12 0
C131 sky130_fd_sc_hd__inv_1_1/Y ZMUX4_0/sky130_fd_sc_hd__mux4_1_0/a_27_413# 0
C132 VDD ZMUX4_0/sky130_fd_sc_hd__mux4_1_0/a_277_47# -0
C133 ZMUX4_0/sky130_fd_sc_hd__mux4_1_0/a_750_97# ZMUX4_0/Z3_1 0
C134 sky130_fd_sc_hd__inv_1_4/A Y0 0.00866f
C135 NLC_4bit_3/x3/a_113_297# A5 0
C136 ZMUX4_0/Z0_0 ZMUX4_0/sky130_fd_sc_hd__mux4_1_0/a_277_47# 0.00566f
C137 ZMUX4_0/sky130_fd_sc_hd__mux4_1_1/a_277_47# ZMUX4_0/Zo_0 0.01305f
C138 ZMUX4_0/sky130_fd_sc_hd__mux4_1_0/a_193_413# ZMUX4_0/Z1_1 0.00891f
C139 NLC_4bit_3/a A7 0
C140 sky130_fd_sc_hd__inv_1_4/A ZMUX4_0/y0 0
C141 Y1 Y4 0
C142 NLC_4bit_1/a A10 0.00256f
C143 NLC_4bit_3/a Y3 0.00348f
C144 ZMUX4_0/Z0_1 BNE_4bit_0/x8/B 0.00496f
C145 A4 NLC_4bit_1/x3/a_113_297# -0
C146 A12 ZMUX4_0/y0 0
C147 ZMUX4_0/sky130_fd_sc_hd__mux4_1_1/a_668_97# ZMUX4_0/Z1_1 0
C148 NLC_4bit_0/x1/a_475_297# BNE_4bit_0/x3/Y 0
C149 ZMUX4_0/sky130_fd_sc_hd__mux4_1_0/a_247_21# ZMUX4_0/Z3_1 0.00455f
C150 A10 NLC_4bit_3/x4/Y 0
C151 ZMUX4_0/Zo_0 VDD 0.23621f
C152 A4 NLC_4bit_2/x4/Y 0
C153 ZMUX4_0/Z0_0 ZMUX4_0/Zo_0 0
C154 NLC_4bit_3/a BNE_4bit_0/x2/Y 0
C155 BNE_4bit_0/x4/a_27_297# NLC_4bit_3/a -0
C156 NLC_4bit_1/x4/Y A0 0
C157 BNE_4bit_0/x8/A NLC_4bit_0/a 0.02248f
C158 NLC_4bit_1/x3/a_199_47# ZMUX4_0/Z0_1 0
C159 ZMUX4_0/y0 ZMUX4_0/sky130_fd_sc_hd__mux4_1_0/a_27_413# -0
C160 A12 ZMUX4_0/sky130_fd_sc_hd__mux4_1_0/a_750_97# 0
C161 Y3 ZMUX4_0/sky130_fd_sc_hd__mux4_1_1/a_1290_413# 0
C162 Y2 ZMUX4_0/Zo_0 0
C163 BNE_4bit_0/x3/Y NLC_4bit_0/a 0.00263f
C164 ZMUX4_0/Z1_0 ZMUX4_0/Z3_0 0.01855f
C165 ZMUX4_0/Zo_1 ZMUX4_0/sky130_fd_sc_hd__mux4_1_0/a_834_97# 0.00459f
C166 sky130_fd_sc_hd__inv_1_1/Y ZMUX4_0/Z3_0 0.00608f
C167 ZMUX4_0/Z2_0 ZMUX4_0/sky130_fd_sc_hd__mux4_1_1/a_277_47# 0
C168 NLC_4bit_2/a A6 0
C169 ZMUX4_0/sky130_fd_sc_hd__mux4_1_0/a_668_97# VDD 0
C170 Y4 VDD 0.23987f
C171 ZMUX4_0/sky130_fd_sc_hd__mux4_1_0/a_668_97# ZMUX4_0/Z0_0 0.00329f
C172 ZMUX4_0/Z0_0 Y4 0
C173 ZMUX4_0/Z2_1 ZMUX4_0/sky130_fd_sc_hd__mux4_1_0/a_277_47# 0.03019f
C174 A12 ZMUX4_0/sky130_fd_sc_hd__mux4_1_0/a_247_21# 0
C175 sky130_fd_sc_hd__inv_1_4/A Y1 0.04457f
C176 ZMUX4_0/sky130_fd_sc_hd__mux4_1_0/a_750_97# ZMUX4_0/sky130_fd_sc_hd__mux4_1_0/a_27_413# 0
C177 A0 A7 0
C178 A10 NLC_4bit_0/a 0
C179 A15 ZMUX4_0/Z3_1 0
C180 Y2 Y4 0
C181 NLC_4bit_1/x1/a_27_297# A8 0
C182 ZMUX4_0/Z2_0 VDD 0.07742f
C183 ZMUX4_0/Z3_1 VDD 0.03954f
C184 Y3 A0 0
C185 sky130_fd_sc_hd__inv_1_3/A ZMUX4_0/Z1_1 0
C186 ZMUX4_0/Z2_0 ZMUX4_0/Z0_0 0
C187 ZMUX4_0/Z1_0 NLC_4bit_2/a 0.20019f
C188 ZMUX4_0/sky130_fd_sc_hd__mux4_1_0/a_1290_413# ZMUX4_0/Z1_1 0.00262f
C189 A14 A12 0
C190 ZMUX4_0/Z2_1 ZMUX4_0/Zo_0 0.00125f
C191 NLC_4bit_1/x4/Y A4 -0
C192 NLC_4bit_2/a NLC_4bit_2/x1/a_27_297# 0
C193 BNE_4bit_0/x8/A NLC_4bit_3/a 0.00615f
C194 ZMUX4_0/Z3_0 ZMUX4_0/y0 0.00474f
C195 ZMUX4_0/sky130_fd_sc_hd__mux4_1_0/a_27_47# VDD -0
C196 BNE_4bit_0/x2/Y A0 0.00738f
C197 ZMUX4_0/sky130_fd_sc_hd__mux4_1_0/a_27_47# ZMUX4_0/Z0_0 0.00153f
C198 Y3 sky130_fd_sc_hd__inv_1_3/A 0.00965f
C199 sky130_fd_sc_hd__nand2_1_0/a_113_47# ZMUX4_0/Z3_1 0
C200 NLC_4bit_3/a BNE_4bit_0/x3/Y 0
C201 BNE_4bit_0/x4/a_27_297# A0 0.00446f
C202 A8 NLC_4bit_1/x2/a_109_297# 0
C203 A3 A5 0
C204 NLC_4bit_2/a NLC_4bit_0/x4/Y 0.01934f
C205 ZMUX4_0/Zo_0 ZMUX4_0/sky130_fd_sc_hd__mux4_1_1/a_27_47# 0
C206 A3 A9 0
C207 ZMUX4_0/Zo_0 sky130_fd_sc_hd__inv_1_2/A 0
C208 ZMUX4_0/sky130_fd_sc_hd__mux4_1_1/a_193_413# ZMUX4_0/Z1_1 0.00219f
C209 sky130_fd_sc_hd__inv_1_4/A VDD 0.03031f
C210 ZMUX4_0/Z1_0 A6 0
C211 ZMUX4_0/y1 NLC_4bit_1/a 0.00217f
C212 A11 NLC_4bit_2/a 0
C213 BNE_4bit_0/x3/A A5 0
C214 A15 A12 0
C215 A4 ZMUX4_0/Z1_1 0.00239f
C216 NLC_4bit_2/x1/a_27_297# A6 0
C217 ZMUX4_0/sky130_fd_sc_hd__mux4_1_1/a_247_21# A8 0
C218 ZMUX4_0/Z2_1 ZMUX4_0/sky130_fd_sc_hd__mux4_1_0/a_668_97# 0
C219 A12 VDD 0.00602f
C220 ZMUX4_0/sky130_fd_sc_hd__mux4_1_0/a_750_97# ZMUX4_0/Z3_0 0
C221 NLC_4bit_3/a A10 0
C222 A4 A7 -0
C223 NLC_4bit_0/x1/a_27_297# NLC_4bit_2/a 0.00373f
C224 NLC_4bit_2/a ZMUX4_0/y0 0.00258f
C225 sky130_fd_sc_hd__inv_1_4/A Y2 0.04515f
C226 A6 NLC_4bit_0/x4/Y 0
C227 ZMUX4_0/Z2_0 ZMUX4_0/Z2_1 0.17329f
C228 ZMUX4_0/Z2_1 ZMUX4_0/Z3_1 0.07624f
C229 ZMUX4_0/sky130_fd_sc_hd__mux4_1_0/a_247_21# ZMUX4_0/Z3_0 0.00272f
C230 ZMUX4_0/y1 ZMUX4_0/Zo_1 0.26605f
C231 NLC_4bit_1/x1/a_475_297# A4 -0
C232 A11 A6 0
C233 A3 A1 -0
C234 sky130_fd_sc_hd__inv_1_1/Y ZMUX4_0/Z1_0 0.05662f
C235 ZMUX4_0/sky130_fd_sc_hd__mux4_1_0/a_27_413# VDD 0.03088f
C236 ZMUX4_0/sky130_fd_sc_hd__mux4_1_0/a_27_413# ZMUX4_0/Z0_0 0
C237 NLC_4bit_1/a A5 0.02613f
C238 A4 NLC_4bit_2/x1/a_475_297# 0
C239 ZMUX4_0/Z3_1 ZMUX4_0/sky130_fd_sc_hd__mux4_1_1/a_27_47# 0
C240 A9 NLC_4bit_1/a 0.00581f
C241 ZMUX4_0/Z2_1 ZMUX4_0/sky130_fd_sc_hd__mux4_1_0/a_27_47# 0.04386f
C242 ZMUX4_0/Z2_0 ZMUX4_0/sky130_fd_sc_hd__mux4_1_1/a_27_47# -0.00195f
C243 A13 ZMUX4_0/sky130_fd_sc_hd__mux4_1_0/a_277_47# 0
C244 A1 BNE_4bit_0/x3/A 0
C245 ZMUX4_0/Z2_0 NLC_4bit_2/x3/a_113_297# 0.00135f
C246 ZMUX4_0/Z1_0 NLC_4bit_0/x4/Y 0.01108f
C247 A5 NLC_4bit_3/x4/Y 0
C248 A14 ZMUX4_0/Z3_0 0
C249 A0 BNE_4bit_0/x3/Y 0.00162f
C250 Y4 BNE_4bit_0/x8/B 0.0081f
C251 A9 NLC_4bit_3/x4/Y -0
C252 ZMUX4_0/Zo_1 ZMUX4_0/sky130_fd_sc_hd__mux4_1_1/a_757_363# 0.00855f
C253 A11 ZMUX4_0/Z1_0 0
C254 ZMUX4_0/Zo_1 A5 0
C255 sky130_fd_sc_hd__nand2_1_3/a_113_47# sky130_fd_sc_hd__inv_1_3/A 0
C256 ZMUX4_0/y1 NLC_4bit_0/a 0.00173f
C257 ZMUX4_0/sky130_fd_sc_hd__mux4_1_1/a_277_47# ZMUX4_0/Z3_0 0.00621f
C258 ZMUX4_0/y1 ZMUX4_0/sky130_fd_sc_hd__mux4_1_1/a_834_97# -0.00254f
C259 ZMUX4_0/Z1_0 Y0 0.01375f
C260 ZMUX4_0/Z2_1 A12 0
C261 ZMUX4_0/sky130_fd_sc_hd__mux4_1_1/a_27_413# ZMUX4_0/Z0_1 0.00124f
C262 ZMUX4_0/Z1_0 ZMUX4_0/y0 0.01281f
C263 sky130_fd_sc_hd__inv_1_1/Y Y0 0.0179f
C264 NLC_4bit_0/x1/a_27_297# ZMUX4_0/Z1_0 0
C265 A9 NLC_4bit_0/x1/a_475_297# 0
C266 A1 NLC_4bit_1/a 0.01685f
C267 A11 NLC_4bit_0/x4/Y 0
C268 sky130_fd_sc_hd__inv_1_1/Y ZMUX4_0/y0 0.12266f
C269 A0 A10 0
C270 A15 ZMUX4_0/Z3_0 0.00124f
C271 NLC_4bit_1/a sky130_fd_sc_hd__inv_1_0/A 0
C272 sky130_fd_sc_hd__inv_1_4/A sky130_fd_sc_hd__inv_1_2/A 0
C273 ZMUX4_0/Z3_0 VDD 0.02773f
C274 A14 NLC_4bit_2/a 0
C275 ZMUX4_0/Z3_0 ZMUX4_0/Z0_0 0.07894f
C276 ZMUX4_0/sky130_fd_sc_hd__mux4_1_1/a_247_21# ZMUX4_0/Z0_1 0.01113f
C277 NLC_4bit_3/x1/a_475_297# ZMUX4_0/y0 0
C278 ZMUX4_0/y0 NLC_4bit_0/x4/Y 0
C279 ZMUX4_0/sky130_fd_sc_hd__mux4_1_1/a_750_97# ZMUX4_0/Z1_1 0.0012f
C280 ZMUX4_0/Z2_1 ZMUX4_0/sky130_fd_sc_hd__mux4_1_0/a_27_413# 0.00163f
C281 NLC_4bit_3/x2/a_109_297# ZMUX4_0/Z1_1 0
C282 A5 NLC_4bit_0/a 0.0012f
C283 ZMUX4_0/y1 sky130_fd_sc_hd__nand2_1_2/a_113_47# 0
C284 NLC_4bit_2/a ZMUX4_0/sky130_fd_sc_hd__mux4_1_1/a_277_47# 0
C285 ZMUX4_0/sky130_fd_sc_hd__mux4_1_0/a_923_363# ZMUX4_0/Z0_1 0
C286 ZMUX4_0/Z1_0 ZMUX4_0/sky130_fd_sc_hd__mux4_1_0/a_750_97# 0.00223f
C287 NLC_4bit_1/x4/Y A8 0
C288 A9 NLC_4bit_0/a 0
C289 A4 BNE_4bit_0/x3/Y 0
C290 NLC_4bit_0/x1/a_27_297# A11 0
C291 sky130_fd_sc_hd__nand2_1_0/a_113_47# ZMUX4_0/Z3_0 0
C292 ZMUX4_0/Zo_1 sky130_fd_sc_hd__inv_1_0/A 0
C293 A1 NLC_4bit_0/x1/a_475_297# -0
C294 ZMUX4_0/Z0_1 NLC_4bit_1/x3/a_113_297# 0
C295 NLC_4bit_0/x1/a_475_297# sky130_fd_sc_hd__inv_1_0/A 0
C296 A14 A6 0
C297 A15 NLC_4bit_2/a 0.00367f
C298 ZMUX4_0/y1 NLC_4bit_3/a 0.02734f
C299 ZMUX4_0/sky130_fd_sc_hd__mux4_1_0/a_750_97# NLC_4bit_3/x1/a_475_297# 0
C300 ZMUX4_0/Z1_0 ZMUX4_0/sky130_fd_sc_hd__mux4_1_0/a_247_21# 0
C301 ZMUX4_0/y1 BNE_4bit_0/x8/a_27_297# 0
C302 NLC_4bit_2/a VDD 0.17759f
C303 ZMUX4_0/Z2_0 A13 0
C304 A13 ZMUX4_0/Z3_1 0.00177f
C305 ZMUX4_0/Z0_1 NLC_4bit_2/x4/Y 0
C306 NLC_4bit_2/a ZMUX4_0/Z0_0 0.00354f
C307 ZMUX4_0/Z1_0 NLC_4bit_0/x3/a_113_297# 0.00312f
C308 A8 ZMUX4_0/Z1_1 0.0047f
C309 ZMUX4_0/Z1_0 Y1 0.20038f
C310 A4 A10 0
C311 ZMUX4_0/Z2_0 NLC_4bit_2/x1/a_281_297# 0
C312 sky130_fd_sc_hd__inv_1_1/Y Y1 0.01083f
C313 A1 NLC_4bit_0/a 0.02284f
C314 ZMUX4_0/y1 ZMUX4_0/sky130_fd_sc_hd__mux4_1_1/a_668_97# -0.00214f
C315 ZMUX4_0/sky130_fd_sc_hd__mux4_1_0/a_247_21# NLC_4bit_3/x1/a_475_297# 0
C316 A8 A7 0.00115f
C317 ZMUX4_0/sky130_fd_sc_hd__mux4_1_1/a_1478_413# ZMUX4_0/Z0_1 0.00311f
C318 sky130_fd_sc_hd__inv_1_0/A NLC_4bit_0/a 0
C319 A15 A6 0
C320 ZMUX4_0/Z2_1 ZMUX4_0/Z3_0 0.17864f
C321 ZMUX4_0/sky130_fd_sc_hd__mux4_1_0/a_750_97# ZMUX4_0/y0 -0
C322 A6 VDD 0.01615f
C323 NLC_4bit_3/a A5 0
C324 ZMUX4_0/y1 ZMUX4_0/sky130_fd_sc_hd__mux4_1_1/a_1290_413# 0.00201f
C325 NLC_4bit_1/x1/a_475_297# A8 0
C326 A9 NLC_4bit_3/a 0.00195f
C327 A11 NLC_4bit_0/x3/a_113_297# 0
C328 ZMUX4_0/Z1_0 ZMUX4_0/sky130_fd_sc_hd__mux4_1_1/a_277_47# 0.0515f
C329 ZMUX4_0/Z3_0 ZMUX4_0/sky130_fd_sc_hd__mux4_1_1/a_27_47# -0
C330 A13 A12 0.01883f
C331 A8 NLC_4bit_2/x1/a_475_297# 0
C332 ZMUX4_0/sky130_fd_sc_hd__mux4_1_0/a_247_21# ZMUX4_0/y0 0
C333 BNE_4bit_0/x4/a_27_297# A8 0
C334 ZMUX4_0/y0 NLC_4bit_0/x3/a_113_297# 0.00309f
C335 Y1 Y0 0.17381f
C336 A14 A11 0.00107f
C337 Y1 ZMUX4_0/y0 0.00627f
C338 sky130_fd_sc_hd__nand2_1_2/a_113_47# sky130_fd_sc_hd__inv_1_0/A 0
C339 ZMUX4_0/Z1_0 VDD 0.93327f
C340 ZMUX4_0/Z1_0 ZMUX4_0/Z0_0 0.2072f
C341 ZMUX4_0/Z2_1 NLC_4bit_2/a 0.03605f
C342 sky130_fd_sc_hd__inv_1_1/Y VDD 0.92092f
C343 NLC_4bit_2/x1/a_27_297# VDD 0
C344 sky130_fd_sc_hd__inv_1_1/Y ZMUX4_0/Z0_0 0.01817f
C345 NLC_4bit_1/x4/Y ZMUX4_0/Z0_1 0
C346 A1 NLC_4bit_3/a 0.00778f
C347 NLC_4bit_2/a NLC_4bit_1/x1/a_281_297# 0
C348 ZMUX4_0/Z3_0 BNE_4bit_0/x8/B 0
C349 NLC_4bit_3/x1/a_475_297# VDD -0
C350 ZMUX4_0/sky130_fd_sc_hd__mux4_1_0/a_757_363# ZMUX4_0/Z1_1 0.01241f
C351 NLC_4bit_3/a sky130_fd_sc_hd__inv_1_0/A 0.2354f
C352 ZMUX4_0/Z1_0 Y2 0.1134f
C353 NLC_4bit_0/x4/Y VDD 0.00376f
C354 ZMUX4_0/Z1_0 sky130_fd_sc_hd__nand2_1_0/a_113_47# 0
C355 NLC_4bit_2/a ZMUX4_0/sky130_fd_sc_hd__mux4_1_1/a_27_47# 0
C356 ZMUX4_0/Z0_0 NLC_4bit_0/x4/Y 0
C357 NLC_4bit_2/a NLC_4bit_2/x3/a_113_297# 0.00367f
C358 ZMUX4_0/y1 sky130_fd_sc_hd__inv_1_3/A 0.16657f
C359 ZMUX4_0/sky130_fd_sc_hd__mux4_1_1/a_277_47# ZMUX4_0/y0 -0.00109f
C360 sky130_fd_sc_hd__inv_1_1/Y Y2 0.00783f
C361 ZMUX4_0/y1 ZMUX4_0/sky130_fd_sc_hd__mux4_1_0/a_1290_413# 0
C362 A11 A15 0.25057f
C363 NLC_4bit_2/a sky130_fd_sc_hd__inv_1_2/A -0
C364 ZMUX4_0/y1 BNE_4bit_0/x4/a_114_47# 0
C365 A11 VDD 0.01597f
C366 ZMUX4_0/sky130_fd_sc_hd__mux4_1_1/a_247_21# ZMUX4_0/Zo_0 0
C367 ZMUX4_0/Z2_1 A6 0
C368 A11 ZMUX4_0/Z0_0 0
C369 NLC_4bit_3/x1/a_27_297# ZMUX4_0/Z1_1 0.00115f
C370 A3 BNE_4bit_0/x3/A 0.00412f
C371 ZMUX4_0/Z0_1 ZMUX4_0/Z1_1 0.11535f
C372 ZMUX4_0/sky130_fd_sc_hd__mux4_1_0/a_1478_413# ZMUX4_0/Z1_1 0.00352f
C373 Y0 VDD 0.20251f
C374 A15 ZMUX4_0/y0 0
C375 NLC_4bit_3/x1/a_27_297# A7 0
C376 A9 A0 0
C377 NLC_4bit_3/a NLC_4bit_3/x3/a_199_47# 0
C378 ZMUX4_0/Z0_1 A7 0.00115f
C379 ZMUX4_0/y0 VDD 0.2985f
C380 NLC_4bit_0/x1/a_27_297# VDD 0
C381 ZMUX4_0/y0 ZMUX4_0/Z0_0 0.25624f
C382 NLC_4bit_2/a BNE_4bit_0/x8/B 0
C383 NLC_4bit_0/x1/a_27_297# ZMUX4_0/Z0_0 0
C384 Y3 ZMUX4_0/Z0_1 0.02393f
C385 A8 BNE_4bit_0/x3/Y 0
C386 A2 NLC_4bit_2/a 0.01431f
C387 ZMUX4_0/y1 A4 0
C388 Y2 Y0 0.02396f
C389 NLC_4bit_1/x1/a_475_297# ZMUX4_0/Z0_1 0
C390 A13 ZMUX4_0/Z3_0 0
C391 ZMUX4_0/Z1_0 ZMUX4_0/Z2_1 0.00111f
C392 ZMUX4_0/sky130_fd_sc_hd__mux4_1_1/a_247_21# Y4 0
C393 sky130_fd_sc_hd__inv_1_1/Y ZMUX4_0/Z2_1 0
C394 ZMUX4_0/Z2_0 ZMUX4_0/sky130_fd_sc_hd__mux4_1_1/a_27_413# 0
C395 Y2 ZMUX4_0/y0 0.0145f
C396 ZMUX4_0/sky130_fd_sc_hd__mux4_1_1/a_27_413# ZMUX4_0/Z3_1 0
C397 A3 NLC_4bit_1/a 0.05622f
C398 ZMUX4_0/Z2_1 NLC_4bit_2/x1/a_27_297# 0
C399 A15 ZMUX4_0/sky130_fd_sc_hd__mux4_1_0/a_750_97# 0
C400 BNE_4bit_0/x2/Y ZMUX4_0/Z0_1 0
C401 ZMUX4_0/Zo_1 ZMUX4_0/sky130_fd_sc_hd__mux4_1_1/a_923_363# 0
C402 ZMUX4_0/sky130_fd_sc_hd__mux4_1_0/a_750_97# VDD -0.00651f
C403 ZMUX4_0/sky130_fd_sc_hd__mux4_1_0/a_750_97# ZMUX4_0/Z0_0 0.00332f
C404 ZMUX4_0/Z1_0 ZMUX4_0/sky130_fd_sc_hd__mux4_1_1/a_27_47# 0
C405 A1 A0 0.01879f
C406 ZMUX4_0/Z1_0 NLC_4bit_2/x3/a_113_297# 0
C407 NLC_4bit_2/a NLC_4bit_1/x3/a_199_47# 0
C408 ZMUX4_0/Z2_1 NLC_4bit_3/x1/a_475_297# 0
C409 NLC_4bit_1/a BNE_4bit_0/x3/A 0.02485f
C410 ZMUX4_0/Z2_0 ZMUX4_0/sky130_fd_sc_hd__mux4_1_1/a_247_21# 0
C411 sky130_fd_sc_hd__inv_1_1/Y ZMUX4_0/sky130_fd_sc_hd__mux4_1_1/a_27_47# 0
C412 A0 sky130_fd_sc_hd__inv_1_0/A 0
C413 ZMUX4_0/sky130_fd_sc_hd__mux4_1_1/a_1478_413# ZMUX4_0/Zo_0 0.0527f
C414 ZMUX4_0/Z1_0 sky130_fd_sc_hd__inv_1_2/A 0.05793f
C415 A2 A6 0.02161f
C416 NLC_4bit_2/a NLC_4bit_0/x1/a_281_297# 0.00512f
C417 sky130_fd_sc_hd__inv_1_1/Y sky130_fd_sc_hd__inv_1_2/A 0.0622f
C418 A4 A5 0.01874f
C419 A11 ZMUX4_0/Z2_1 0
C420 ZMUX4_0/sky130_fd_sc_hd__mux4_1_0/a_247_21# VDD 0.00159f
C421 ZMUX4_0/sky130_fd_sc_hd__mux4_1_0/a_247_21# ZMUX4_0/Z0_0 0.01101f
C422 ZMUX4_0/Z3_1 ZMUX4_0/sky130_fd_sc_hd__mux4_1_0/a_923_363# 0
C423 VDD NLC_4bit_0/x3/a_113_297# 0
C424 A1 sky130_fd_sc_hd__inv_1_3/A 0
C425 A13 NLC_4bit_2/a 0.00101f
C426 A9 A4 0
C427 A3 NLC_4bit_0/x1/a_475_297# -0
C428 ZMUX4_0/Z0_0 NLC_4bit_0/x3/a_113_297# 0.00186f
C429 NLC_4bit_3/a NLC_4bit_2/x3/a_199_47# 0
C430 sky130_fd_sc_hd__inv_1_3/A sky130_fd_sc_hd__inv_1_0/A 0
C431 Y1 VDD 0.17143f
C432 Y1 ZMUX4_0/Z0_0 0
C433 ZMUX4_0/Z2_1 ZMUX4_0/y0 0.04227f
C434 ZMUX4_0/Z1_0 BNE_4bit_0/x8/B 0.00775f
C435 A11 ZMUX4_0/sky130_fd_sc_hd__mux4_1_1/a_27_47# 0
C436 A14 A15 0.02479f
C437 NLC_4bit_2/x1/a_281_297# NLC_4bit_2/a 0
C438 sky130_fd_sc_hd__inv_1_1/Y BNE_4bit_0/x8/B 0
C439 ZMUX4_0/Z1_0 A2 0
C440 A14 VDD 0.00102f
C441 ZMUX4_0/Z3_0 ZMUX4_0/sky130_fd_sc_hd__mux4_1_0/a_193_47# 0
C442 ZMUX4_0/Z2_0 NLC_4bit_2/x4/Y 0.00195f
C443 Y1 Y2 0.19676f
C444 ZMUX4_0/y0 ZMUX4_0/sky130_fd_sc_hd__mux4_1_1/a_27_47# -0.00224f
C445 Y0 sky130_fd_sc_hd__inv_1_2/A 0
C446 NLC_4bit_1/a NLC_4bit_3/x4/Y 0
C447 A13 A6 0
C448 sky130_fd_sc_hd__nand2_1_3/a_113_47# ZMUX4_0/Z0_1 0
C449 A3 NLC_4bit_0/a 0.01462f
C450 BNE_4bit_0/x8/A ZMUX4_0/Z0_1 0
C451 ZMUX4_0/Zo_0 ZMUX4_0/sky130_fd_sc_hd__mux4_1_1/a_193_47# 0
C452 ZMUX4_0/y0 sky130_fd_sc_hd__inv_1_2/A 0.12727f
C453 ZMUX4_0/sky130_fd_sc_hd__mux4_1_1/a_277_47# VDD -0.00222f
C454 ZMUX4_0/sky130_fd_sc_hd__mux4_1_1/a_193_413# sky130_fd_sc_hd__inv_1_0/A 0
C455 ZMUX4_0/sky130_fd_sc_hd__mux4_1_1/a_277_47# ZMUX4_0/Z0_0 0.05788f
C456 ZMUX4_0/sky130_fd_sc_hd__mux4_1_0/a_277_47# ZMUX4_0/Z1_1 0.0347f
C457 ZMUX4_0/Z2_1 ZMUX4_0/sky130_fd_sc_hd__mux4_1_0/a_750_97# 0
C458 BNE_4bit_0/x3/Y ZMUX4_0/Z0_1 0
C459 ZMUX4_0/Z2_0 ZMUX4_0/sky130_fd_sc_hd__mux4_1_1/a_1478_413# 0
C460 ZMUX4_0/Z1_0 NLC_4bit_1/x3/a_199_47# 0
C461 NLC_4bit_2/x1/a_281_297# A6 0
C462 BNE_4bit_0/x3/A NLC_4bit_0/a 0
C463 A11 A2 0
C464 ZMUX4_0/Z1_0 NLC_4bit_0/x1/a_281_297# 0
C465 NLC_4bit_0/x1/a_475_297# NLC_4bit_1/a 0.00173f
C466 ZMUX4_0/y1 ZMUX4_0/sky130_fd_sc_hd__mux4_1_1/a_750_97# 0.00395f
C467 A15 VDD -0
C468 ZMUX4_0/Z0_0 VDD 0.30876f
C469 ZMUX4_0/Z2_1 ZMUX4_0/sky130_fd_sc_hd__mux4_1_0/a_247_21# 0.00978f
C470 ZMUX4_0/y0 BNE_4bit_0/x8/B 0.00143f
C471 A13 ZMUX4_0/Z1_0 0
C472 ZMUX4_0/Z0_1 A10 0
C473 sky130_fd_sc_hd__nand2_1_0/a_113_47# VDD -0
C474 sky130_fd_sc_hd__inv_1_4/A ZMUX4_0/sky130_fd_sc_hd__mux4_1_1/a_1478_413# 0
C475 Y2 VDD 0.06136f
C476 Y3 ZMUX4_0/Zo_0 0
C477 Y2 ZMUX4_0/Z0_0 0.00379f
C478 sky130_fd_sc_hd__nand2_1_0/a_113_47# ZMUX4_0/Z0_0 0
C479 NLC_4bit_1/a NLC_4bit_0/a 0.17501f
C480 ZMUX4_0/Z0_1 ZMUX4_0/sky130_fd_sc_hd__mux4_1_0/a_834_97# 0.00414f
C481 ZMUX4_0/Z2_0 NLC_4bit_1/x4/Y 0
C482 A3 NLC_4bit_3/a 0.00749f
C483 ZMUX4_0/Z2_0 ZMUX4_0/sky130_fd_sc_hd__mux4_1_1/a_193_47# 0
C484 Y1 sky130_fd_sc_hd__inv_1_2/A 0
C485 A13 A11 0
C486 ZMUX4_0/sky130_fd_sc_hd__mux4_1_1/a_27_413# ZMUX4_0/Z3_0 0.00299f
C487 ZMUX4_0/sky130_fd_sc_hd__mux4_1_0/a_668_97# ZMUX4_0/Z1_1 0.00158f
C488 ZMUX4_0/Z2_1 ZMUX4_0/sky130_fd_sc_hd__mux4_1_1/a_277_47# 0.01968f
C489 NLC_4bit_3/a BNE_4bit_0/x3/A 0
C490 NLC_4bit_2/a NLC_4bit_1/x1/a_27_297# 0
C491 ZMUX4_0/sky130_fd_sc_hd__mux4_1_1/a_834_97# ZMUX4_0/Zo_1 0.00209f
C492 A13 ZMUX4_0/y0 0
C493 ZMUX4_0/sky130_fd_sc_hd__mux4_1_1/a_247_21# ZMUX4_0/Z3_0 0.00805f
C494 Y3 Y4 0
C495 A15 ZMUX4_0/Z2_1 0.00125f
C496 ZMUX4_0/sky130_fd_sc_hd__mux4_1_1/a_277_47# ZMUX4_0/sky130_fd_sc_hd__mux4_1_1/a_27_47# -0.00177f
C497 NLC_4bit_0/x1/a_475_297# NLC_4bit_0/a 0.00601f
C498 ZMUX4_0/Z2_0 ZMUX4_0/Z1_1 0.04141f
C499 ZMUX4_0/Z3_1 ZMUX4_0/Z1_1 0.09937f
C500 ZMUX4_0/Z2_1 VDD 0.23157f
C501 ZMUX4_0/Z2_1 ZMUX4_0/Z0_0 0.03934f
C502 ZMUX4_0/Z3_1 A7 0
C503 ZMUX4_0/Z2_0 A7 0
C504 A8 A5 0
C505 VDD NLC_4bit_1/x1/a_281_297# 0.00216f
C506 NLC_4bit_2/a ZMUX4_0/sky130_fd_sc_hd__mux4_1_1/a_27_413# 0.0025f
C507 A9 A8 0.01883f
C508 ZMUX4_0/sky130_fd_sc_hd__mux4_1_0/a_27_47# ZMUX4_0/Z1_1 0.00185f
C509 ZMUX4_0/sky130_fd_sc_hd__mux4_1_1/a_27_47# VDD -0
C510 NLC_4bit_3/a NLC_4bit_1/a 0.07923f
C511 NLC_4bit_2/x3/a_113_297# VDD -0
C512 A13 ZMUX4_0/sky130_fd_sc_hd__mux4_1_0/a_750_97# 0
C513 ZMUX4_0/Z0_0 ZMUX4_0/sky130_fd_sc_hd__mux4_1_1/a_27_47# 0.00636f
C514 sky130_fd_sc_hd__inv_1_2/A VDD 0.01802f
C515 ZMUX4_0/Z0_0 sky130_fd_sc_hd__inv_1_2/A 0.05849f
C516 ZMUX4_0/sky130_fd_sc_hd__mux4_1_1/a_277_47# BNE_4bit_0/x8/B 0
C517 ZMUX4_0/Z3_0 NLC_4bit_2/x4/Y 0
C518 NLC_4bit_2/a ZMUX4_0/sky130_fd_sc_hd__mux4_1_1/a_247_21# 0
C519 NLC_4bit_3/a NLC_4bit_3/x4/Y 0
C520 ZMUX4_0/Z2_0 NLC_4bit_2/x1/a_475_297# 0
C521 A3 A0 -0
C522 A13 ZMUX4_0/sky130_fd_sc_hd__mux4_1_0/a_247_21# 0
C523 sky130_fd_sc_hd__nand2_1_3/a_113_47# ZMUX4_0/Zo_0 0
C524 ZMUX4_0/Zo_1 NLC_4bit_3/a 0
C525 A12 ZMUX4_0/Z1_1 0.00458f
C526 Y2 sky130_fd_sc_hd__inv_1_2/A 0.01666f
C527 sky130_fd_sc_hd__nand2_1_0/a_113_47# sky130_fd_sc_hd__inv_1_2/A 0
C528 ZMUX4_0/y0 ZMUX4_0/sky130_fd_sc_hd__mux4_1_0/a_193_47# -0
C529 ZMUX4_0/sky130_fd_sc_hd__mux4_1_0/a_193_413# ZMUX4_0/Zo_1 0
C530 sky130_fd_sc_hd__inv_1_4/A Y3 0.00897f
C531 A12 A7 0
C532 A1 A8 0
C533 VDD BNE_4bit_0/x8/B 0.03342f
C534 BNE_4bit_0/x3/A A0 0.00108f
C535 NLC_4bit_3/a NLC_4bit_0/x1/a_475_297# 0
C536 ZMUX4_0/Z0_0 BNE_4bit_0/x8/B 0
C537 NLC_4bit_2/a NLC_4bit_1/x3/a_113_297# 0.00497f
C538 A2 VDD 0.02371f
C539 A2 ZMUX4_0/Z0_0 0
C540 ZMUX4_0/y1 ZMUX4_0/Z0_1 0.03232f
C541 ZMUX4_0/Zo_1 ZMUX4_0/sky130_fd_sc_hd__mux4_1_1/a_668_97# 0.00247f
C542 A13 A14 0.02273f
C543 NLC_4bit_2/a NLC_4bit_2/x4/Y 0
C544 ZMUX4_0/sky130_fd_sc_hd__mux4_1_0/a_27_413# ZMUX4_0/Z1_1 0.00781f
C545 Y2 BNE_4bit_0/x8/B 0
C546 ZMUX4_0/Z1_0 ZMUX4_0/sky130_fd_sc_hd__mux4_1_1/a_27_413# 0
C547 BNE_4bit_0/x8/A Y4 0
C548 sky130_fd_sc_hd__nand2_1_1/a_113_47# sky130_fd_sc_hd__inv_1_0/A 0
C549 ZMUX4_0/Zo_1 ZMUX4_0/sky130_fd_sc_hd__mux4_1_1/a_1290_413# 0.00184f
C550 A11 NLC_4bit_1/x1/a_27_297# 0
C551 sky130_fd_sc_hd__inv_1_1/Y ZMUX4_0/sky130_fd_sc_hd__mux4_1_1/a_27_413# 0
C552 NLC_4bit_3/a NLC_4bit_0/a 0.253f
C553 ZMUX4_0/Z2_1 ZMUX4_0/sky130_fd_sc_hd__mux4_1_1/a_27_47# 0.04352f
C554 ZMUX4_0/Z2_1 NLC_4bit_2/x3/a_113_297# 0.00567f
C555 NLC_4bit_2/a NLC_4bit_0/x2/a_109_297# 0
C556 NLC_4bit_1/a A0 0.0448f
C557 ZMUX4_0/sky130_fd_sc_hd__mux4_1_1/a_757_363# ZMUX4_0/Z0_1 0.00643f
C558 ZMUX4_0/Z1_0 ZMUX4_0/sky130_fd_sc_hd__mux4_1_1/a_247_21# 0
C559 NLC_4bit_0/x1/a_281_297# ZMUX4_0/Z0_0 0
C560 ZMUX4_0/y1 BNE_4bit_0/x5/a_113_47# -0
C561 A3 A4 0
C562 NLC_4bit_1/x4/Y ZMUX4_0/Z3_0 0
C563 ZMUX4_0/Z0_1 A5 0
C564 A13 A15 -0
C565 ZMUX4_0/Z3_0 ZMUX4_0/sky130_fd_sc_hd__mux4_1_1/a_193_47# -0
C566 sky130_fd_sc_hd__inv_1_1/Y ZMUX4_0/sky130_fd_sc_hd__mux4_1_1/a_247_21# 0
C567 A6 NLC_4bit_2/x4/Y 0
C568 A13 VDD 0.00349f
C569 A9 ZMUX4_0/Z0_1 0
C570 A4 BNE_4bit_0/x3/A 0
C571 BNE_4bit_0/x4/a_114_47# NLC_4bit_1/a 0
C572 ZMUX4_0/Z1_0 NLC_4bit_1/x3/a_113_297# 0.00177f
C573 NLC_4bit_0/x1/a_475_297# A0 -0
C574 ZMUX4_0/sky130_fd_sc_hd__mux4_1_1/a_27_413# ZMUX4_0/y0 -0
C575 ZMUX4_0/Z3_0 ZMUX4_0/Z1_1 0.2133f
C576 ZMUX4_0/Z1_0 NLC_4bit_2/x4/Y 0
C577 ZMUX4_0/Zo_1 sky130_fd_sc_hd__inv_1_3/A 0.01228f
C578 NLC_4bit_1/x4/Y NLC_4bit_2/a 0.02681f
C579 sky130_fd_sc_hd__inv_1_4/A sky130_fd_sc_hd__nand2_1_3/a_113_47# 0
C580 ZMUX4_0/sky130_fd_sc_hd__mux4_1_0/a_1290_413# ZMUX4_0/Zo_1 0.04427f
C581 NLC_4bit_3/a NLC_4bit_0/x3/a_199_47# 0
C582 ZMUX4_0/Z3_0 A7 0
C583 sky130_fd_sc_hd__inv_1_2/A BNE_4bit_0/x8/B 0
C584 A1 ZMUX4_0/Z0_1 0
C585 ZMUX4_0/sky130_fd_sc_hd__mux4_1_1/a_247_21# ZMUX4_0/y0 0.00499f
C586 BNE_4bit_0/x8/a_27_297# NLC_4bit_3/a 0.00242f
C587 Y3 ZMUX4_0/Z3_0 0
C588 A4 NLC_4bit_1/a 0.05433f
C589 ZMUX4_0/Z0_1 sky130_fd_sc_hd__inv_1_0/A 0.03234f
C590 ZMUX4_0/Z1_0 ZMUX4_0/sky130_fd_sc_hd__mux4_1_1/a_1478_413# 0.01146f
C591 NLC_4bit_0/x4/Y NLC_4bit_2/x4/Y 0
C592 A11 NLC_4bit_1/x3/a_113_297# 0
C593 A0 NLC_4bit_0/a 0.02249f
C594 sky130_fd_sc_hd__inv_1_1/Y ZMUX4_0/sky130_fd_sc_hd__mux4_1_1/a_1478_413# 0.00431f
C595 A4 NLC_4bit_3/x4/Y 0
C596 ZMUX4_0/sky130_fd_sc_hd__mux4_1_0/a_193_47# VDD -0
C597 A11 NLC_4bit_2/x4/Y 0
C598 NLC_4bit_2/a ZMUX4_0/Z1_1 0.07577f
C599 ZMUX4_0/y1 ZMUX4_0/sky130_fd_sc_hd__mux4_1_0/a_277_47# -0.00139f
C600 A13 ZMUX4_0/Z2_1 0.04081f
C601 NLC_4bit_2/a A7 0.18675f
C602 BNE_4bit_0/x4/a_114_47# NLC_4bit_0/a 0
C603 ZMUX4_0/y0 NLC_4bit_2/x4/Y 0
C604 NLC_4bit_2/x1/a_281_297# ZMUX4_0/Z2_1 0
C605 ZMUX4_0/y0 NLC_4bit_3/x1/a_281_297# 0
C606 NLC_4bit_1/x1/a_475_297# NLC_4bit_2/a 0
C607 ZMUX4_0/y1 ZMUX4_0/Zo_0 0.00218f
C608 ZMUX4_0/sky130_fd_sc_hd__mux4_1_1/a_1478_413# Y0 0
C609 ZMUX4_0/Z1_0 NLC_4bit_1/x4/Y 0.00479f
C610 A6 ZMUX4_0/Z1_1 0
C611 ZMUX4_0/sky130_fd_sc_hd__mux4_1_1/a_1478_413# ZMUX4_0/y0 -0
C612 NLC_4bit_2/a BNE_4bit_0/x2/Y 0.00757f
C613 NLC_4bit_2/a NLC_4bit_2/x1/a_475_297# 0
C614 BNE_4bit_0/x4/a_27_297# NLC_4bit_2/a 0.00918f
C615 A7 A6 0.02312f
C616 NLC_4bit_1/x1/a_27_297# VDD 0.00119f
C617 sky130_fd_sc_hd__nand2_1_2/a_113_47# sky130_fd_sc_hd__inv_1_3/A 0
C618 NLC_4bit_3/a A0 0.00739f
C619 A4 NLC_4bit_0/a 0
C620 NLC_4bit_3/x3/a_113_297# ZMUX4_0/Z0_1 0
C621 NLC_4bit_1/x4/Y NLC_4bit_0/x4/Y 0.00495f
C622 ZMUX4_0/y1 ZMUX4_0/sky130_fd_sc_hd__mux4_1_0/a_668_97# -0.00214f
C623 ZMUX4_0/y1 Y4 0.03172f
C624 A4 NLC_4bit_2/x2/a_109_297# 0
C625 ZMUX4_0/Z2_1 ZMUX4_0/sky130_fd_sc_hd__mux4_1_0/a_193_47# 0.00134f
C626 ZMUX4_0/Z1_0 ZMUX4_0/Z1_1 0.03859f
C627 NLC_4bit_3/a sky130_fd_sc_hd__inv_1_3/A 0
C628 A11 NLC_4bit_1/x4/Y 0
C629 ZMUX4_0/sky130_fd_sc_hd__mux4_1_1/a_277_47# ZMUX4_0/sky130_fd_sc_hd__mux4_1_1/a_247_21# -0
C630 sky130_fd_sc_hd__inv_1_1/Y ZMUX4_0/Z1_1 0.00105f
C631 ZMUX4_0/sky130_fd_sc_hd__mux4_1_0/a_247_21# NLC_4bit_3/x1/a_281_297# 0
C632 NLC_4bit_2/x1/a_27_297# ZMUX4_0/Z1_1 0.00117f
C633 A3 A8 0
C634 NLC_4bit_1/x2/a_109_297# VDD 0
C635 ZMUX4_0/Z1_0 A7 -0.00167f
C636 NLC_4bit_0/x3/a_113_297# NLC_4bit_2/x4/Y 0
C637 ZMUX4_0/sky130_fd_sc_hd__mux4_1_1/a_27_413# VDD 0.03088f
C638 ZMUX4_0/sky130_fd_sc_hd__mux4_1_1/a_27_413# ZMUX4_0/Z0_0 0.00488f
C639 NLC_4bit_2/x1/a_27_297# A7 0
C640 ZMUX4_0/Z1_0 Y3 0.07641f
C641 NLC_4bit_1/x4/Y ZMUX4_0/y0 0
C642 NLC_4bit_3/x1/a_475_297# ZMUX4_0/Z1_1 0.00244f
C643 ZMUX4_0/y1 ZMUX4_0/Z3_1 -0
C644 ZMUX4_0/y0 ZMUX4_0/sky130_fd_sc_hd__mux4_1_1/a_193_47# -0
C645 ZMUX4_0/Z2_0 ZMUX4_0/y1 0.00427f
C646 sky130_fd_sc_hd__inv_1_1/Y Y3 0.0069f
C647 A14 NLC_4bit_2/x4/Y 0
C648 ZMUX4_0/sky130_fd_sc_hd__mux4_1_1/a_247_21# VDD 0.01845f
C649 A7 NLC_4bit_0/x4/Y 0.00431f
C650 ZMUX4_0/sky130_fd_sc_hd__mux4_1_1/a_247_21# ZMUX4_0/Z0_0 0.04841f
C651 A11 ZMUX4_0/Z1_1 0.00869f
C652 ZMUX4_0/sky130_fd_sc_hd__mux4_1_1/a_193_413# NLC_4bit_3/a 0.00164f
C653 Y3 NLC_4bit_0/x4/Y 0
C654 ZMUX4_0/y1 ZMUX4_0/sky130_fd_sc_hd__mux4_1_0/a_27_47# 0
C655 ZMUX4_0/sky130_fd_sc_hd__mux4_1_0/a_923_363# VDD -0
C656 BNE_4bit_0/x8/A NLC_4bit_2/a 0
C657 ZMUX4_0/sky130_fd_sc_hd__mux4_1_1/a_277_47# NLC_4bit_2/x4/Y 0.00156f
C658 A4 NLC_4bit_3/a 0
C659 ZMUX4_0/sky130_fd_sc_hd__mux4_1_0/a_923_363# ZMUX4_0/Z0_0 0
C660 ZMUX4_0/Zo_1 ZMUX4_0/sky130_fd_sc_hd__mux4_1_1/a_750_97# 0.01445f
C661 A11 A7 0.02593f
C662 NLC_4bit_2/a BNE_4bit_0/x3/Y 0.00259f
C663 ZMUX4_0/Z3_0 ZMUX4_0/sky130_fd_sc_hd__mux4_1_0/a_834_97# 0
C664 ZMUX4_0/Zo_0 sky130_fd_sc_hd__inv_1_0/A 0
C665 ZMUX4_0/sky130_fd_sc_hd__mux4_1_1/a_247_21# Y2 0
C666 ZMUX4_0/y0 ZMUX4_0/Z1_1 0.02878f
C667 NLC_4bit_3/x3/a_199_47# ZMUX4_0/sky130_fd_sc_hd__mux4_1_0/a_277_47# 0
C668 VDD NLC_4bit_1/x3/a_113_297# 0.00123f
C669 NLC_4bit_1/a A8 0.00472f
C670 ZMUX4_0/Z3_1 A5 0
C671 ZMUX4_0/Z2_0 A5 0
C672 ZMUX4_0/y1 sky130_fd_sc_hd__inv_1_4/A 0.00142f
C673 BNE_4bit_0/x2/Y NLC_4bit_0/x4/Y 0
C674 A15 NLC_4bit_2/x4/Y 0.00721f
C675 NLC_4bit_1/x1/a_475_297# A11 0
C676 Y3 Y0 0.01869f
C677 ZMUX4_0/sky130_fd_sc_hd__mux4_1_1/a_277_47# ZMUX4_0/sky130_fd_sc_hd__mux4_1_1/a_1478_413# -0.00103f
C678 ZMUX4_0/Z2_0 A9 0.04526f
C679 VDD NLC_4bit_2/x4/Y 0.00312f
C680 Y3 ZMUX4_0/y0 0.01091f
C681 A11 BNE_4bit_0/x2/Y 0
C682 A8 NLC_4bit_3/x4/Y -0
C683 ZMUX4_0/sky130_fd_sc_hd__mux4_1_1/a_923_363# ZMUX4_0/Z0_1 0
C684 ZMUX4_0/Z2_1 ZMUX4_0/sky130_fd_sc_hd__mux4_1_1/a_27_413# 0.01193f
C685 NLC_4bit_2/a A10 0
C686 ZMUX4_0/sky130_fd_sc_hd__mux4_1_0/a_750_97# ZMUX4_0/Z1_1 0.05279f
C687 ZMUX4_0/sky130_fd_sc_hd__mux4_1_1/a_1478_413# VDD 0.00258f
C688 BNE_4bit_0/x4/a_27_297# ZMUX4_0/y0 -0
C689 NLC_4bit_0/x1/a_475_297# A8 0
C690 ZMUX4_0/y1 ZMUX4_0/sky130_fd_sc_hd__mux4_1_0/a_27_413# 0
C691 ZMUX4_0/Z2_1 ZMUX4_0/sky130_fd_sc_hd__mux4_1_1/a_247_21# 0.00512f
C692 A3 ZMUX4_0/Z0_1 -0
C693 ZMUX4_0/sky130_fd_sc_hd__mux4_1_0/a_247_21# ZMUX4_0/Z1_1 0.02574f
C694 ZMUX4_0/Z1_0 sky130_fd_sc_hd__nand2_1_3/a_113_47# 0
C695 ZMUX4_0/Z1_0 BNE_4bit_0/x8/A 0.00178f
C696 A12 A5 0
C697 ZMUX4_0/Z2_0 sky130_fd_sc_hd__inv_1_0/A 0
C698 sky130_fd_sc_hd__inv_1_1/Y sky130_fd_sc_hd__nand2_1_3/a_113_47# 0
C699 ZMUX4_0/Z3_1 sky130_fd_sc_hd__inv_1_0/A 0.00155f
C700 sky130_fd_sc_hd__inv_1_1/Y BNE_4bit_0/x8/A 0.00128f
C701 BNE_4bit_0/x3/A ZMUX4_0/Z0_1 0
C702 A6 A10 0.01993f
C703 A4 A0 0.00982f
C704 ZMUX4_0/sky130_fd_sc_hd__mux4_1_1/a_247_21# NLC_4bit_2/x3/a_113_297# 0
C705 ZMUX4_0/Z2_1 NLC_4bit_1/x3/a_113_297# 0
C706 A8 NLC_4bit_0/a 0
C707 BNE_4bit_0/x8/A NLC_4bit_0/x4/Y 0
C708 A14 ZMUX4_0/Z1_1 0.00219f
C709 ZMUX4_0/sky130_fd_sc_hd__mux4_1_1/a_27_413# BNE_4bit_0/x8/B 0
C710 ZMUX4_0/sky130_fd_sc_hd__mux4_1_0/a_27_47# sky130_fd_sc_hd__inv_1_0/A 0
C711 Y1 Y3 0.02006f
C712 ZMUX4_0/Z2_1 NLC_4bit_2/x4/Y 0
C713 BNE_4bit_0/x3/Y NLC_4bit_0/x4/Y 0
C714 NLC_4bit_1/x4/Y VDD 0.00418f
C715 NLC_4bit_1/x4/Y ZMUX4_0/Z0_0 0
C716 ZMUX4_0/sky130_fd_sc_hd__mux4_1_1/a_193_47# VDD -0
C717 ZMUX4_0/Z2_1 NLC_4bit_3/x1/a_281_297# 0
C718 ZMUX4_0/Z0_0 ZMUX4_0/sky130_fd_sc_hd__mux4_1_1/a_193_47# 0
C719 NLC_4bit_3/a ZMUX4_0/sky130_fd_sc_hd__mux4_1_1/a_750_97# 0
C720 ZMUX4_0/sky130_fd_sc_hd__mux4_1_1/a_277_47# ZMUX4_0/Z1_1 0.00275f
C721 NLC_4bit_3/x1/a_27_297# NLC_4bit_1/a 0
C722 ZMUX4_0/sky130_fd_sc_hd__mux4_1_1/a_247_21# BNE_4bit_0/x8/B 0
C723 NLC_4bit_1/a ZMUX4_0/Z0_1 0.01742f
C724 ZMUX4_0/Z2_1 ZMUX4_0/sky130_fd_sc_hd__mux4_1_1/a_1478_413# 0
C725 ZMUX4_0/y1 ZMUX4_0/Z3_0 0.00129f
C726 BNE_4bit_0/x8/A ZMUX4_0/y0 0
C727 ZMUX4_0/Z1_0 ZMUX4_0/sky130_fd_sc_hd__mux4_1_0/a_834_97# 0.00217f
C728 ZMUX4_0/Zo_1 ZMUX4_0/sky130_fd_sc_hd__mux4_1_0/a_757_363# 0.00745f
C729 A15 ZMUX4_0/Z1_1 0.00848f
C730 A10 NLC_4bit_0/x4/Y 0
C731 VDD ZMUX4_0/Z1_1 0.26204f
C732 ZMUX4_0/Z0_0 ZMUX4_0/Z1_1 0.05311f
C733 A15 A7 0
C734 A7 VDD 0.01613f
C735 ZMUX4_0/Zo_1 ZMUX4_0/Z0_1 0.17498f
C736 A11 A10 0.02479f
C737 NLC_4bit_3/x3/a_113_297# ZMUX4_0/Z3_1 0.00163f
C738 ZMUX4_0/Zo_1 ZMUX4_0/sky130_fd_sc_hd__mux4_1_0/a_1478_413# 0.05543f
C739 NLC_4bit_3/a A8 0
C740 Y3 VDD 0.05377f
C741 NLC_4bit_0/x1/a_475_297# ZMUX4_0/Z0_1 0
C742 ZMUX4_0/sky130_fd_sc_hd__mux4_1_0/a_27_413# sky130_fd_sc_hd__inv_1_0/A 0
C743 Y3 ZMUX4_0/Z0_0 0.09924f
C744 ZMUX4_0/Z3_0 A5 0
C745 NLC_4bit_1/x1/a_475_297# VDD 0.00172f
C746 ZMUX4_0/y1 NLC_4bit_2/a 0.01246f
C747 NLC_4bit_0/x1/a_27_297# A10 0
C748 A9 ZMUX4_0/Z3_0 0
C749 BNE_4bit_0/x2/Y VDD 0.01283f
C750 ZMUX4_0/Z2_1 NLC_4bit_1/x4/Y 0
C751 ZMUX4_0/y0 ZMUX4_0/sky130_fd_sc_hd__mux4_1_0/a_834_97# -0
C752 BNE_4bit_0/x4/a_27_297# VDD -0
C753 Y3 Y2 0.73111f
C754 ZMUX4_0/Z2_1 ZMUX4_0/sky130_fd_sc_hd__mux4_1_1/a_193_47# 0.00128f
C755 NLC_4bit_2/x1/a_281_297# ZMUX4_0/sky130_fd_sc_hd__mux4_1_1/a_247_21# 0
C756 ZMUX4_0/Z0_1 NLC_4bit_0/a 0.01093f
C757 ZMUX4_0/sky130_fd_sc_hd__mux4_1_1/a_834_97# ZMUX4_0/Z0_1 0.00156f
C758 NLC_4bit_1/x4/Y NLC_4bit_2/x3/a_113_297# 0
C759 ZMUX4_0/y1 A6 0
C760 NLC_4bit_2/a A5 0.00924f
C761 ZMUX4_0/Z2_1 ZMUX4_0/Z1_1 0.08519f
C762 ZMUX4_0/sky130_fd_sc_hd__mux4_1_1/a_750_97# sky130_fd_sc_hd__inv_1_3/A 0
C763 A9 NLC_4bit_2/a 0.00176f
C764 ZMUX4_0/Z3_0 sky130_fd_sc_hd__inv_1_0/A 0.00572f
C765 ZMUX4_0/Z2_1 A7 0
C766 NLC_4bit_1/x1/a_281_297# ZMUX4_0/Z1_1 -0
C767 BNE_4bit_0/x5/a_113_47# NLC_4bit_0/a 0
C768 ZMUX4_0/sky130_fd_sc_hd__mux4_1_1/a_27_47# ZMUX4_0/Z1_1 0.00166f
C769 sky130_fd_sc_hd__nand2_1_2/a_113_47# ZMUX4_0/Z0_1 0
C770 NLC_4bit_2/x3/a_113_297# ZMUX4_0/Z1_1 0.00738f
C771 ZMUX4_0/y1 ZMUX4_0/Z1_0 0.76241f
C772 sky130_fd_sc_hd__inv_1_2/A ZMUX4_0/Z1_1 0
C773 NLC_4bit_1/x4/Y A2 0
C774 A5 A6 0.02267f
C775 ZMUX4_0/y1 sky130_fd_sc_hd__inv_1_1/Y 0.47739f
C776 ZMUX4_0/sky130_fd_sc_hd__mux4_1_0/a_277_47# NLC_4bit_3/x4/Y 0.00156f
C777 sky130_fd_sc_hd__nand2_1_3/a_113_47# VDD -0
C778 ZMUX4_0/Z0_1 NLC_4bit_0/x3/a_199_47# 0
C779 A9 A6 0
C780 A14 A10 0.02253f
C781 BNE_4bit_0/x8/A VDD 0.00902f
C782 ZMUX4_0/Z2_1 BNE_4bit_0/x2/Y 0
C783 ZMUX4_0/Z2_1 NLC_4bit_2/x1/a_475_297# 0
C784 ZMUX4_0/Z3_0 NLC_4bit_3/x3/a_199_47# 0
C785 A1 NLC_4bit_2/a 0.01709f
C786 NLC_4bit_3/a ZMUX4_0/Z0_1 0.11437f
C787 BNE_4bit_0/x8/a_27_297# ZMUX4_0/Z0_1 0.00495f
C788 Y3 sky130_fd_sc_hd__inv_1_2/A 0.04052f
C789 BNE_4bit_0/x3/Y VDD 0.00785f
C790 NLC_4bit_2/a sky130_fd_sc_hd__inv_1_0/A 0.004f
C791 ZMUX4_0/Zo_1 ZMUX4_0/sky130_fd_sc_hd__mux4_1_0/a_277_47# 0.0194f
C792 NLC_4bit_1/x4/Y NLC_4bit_1/x3/a_199_47# -0
C793 ZMUX4_0/Z1_0 ZMUX4_0/sky130_fd_sc_hd__mux4_1_1/a_757_363# 0.00283f
C794 BNE_4bit_0/x8/A Y2 0
C795 ZMUX4_0/Z1_0 A5 0.00423f
C796 sky130_fd_sc_hd__inv_1_1/Y ZMUX4_0/sky130_fd_sc_hd__mux4_1_1/a_757_363# 0
C797 sky130_fd_sc_hd__inv_1_1/Y A5 0
C798 sky130_fd_sc_hd__nand2_1_1/a_113_47# sky130_fd_sc_hd__inv_1_3/A 0
C799 ZMUX4_0/sky130_fd_sc_hd__mux4_1_1/a_668_97# ZMUX4_0/Z0_1 0.00366f
C800 ZMUX4_0/y1 Y0 0
C801 ZMUX4_0/Z1_0 A9 0
C802 ZMUX4_0/y1 BNE_4bit_0/x4/a_285_47# -0
C803 Y3 BNE_4bit_0/x8/B 0
C804 A15 A10 0.00107f
C805 A2 A7 0.00106f
C806 A10 VDD 0.01576f
C807 A13 NLC_4bit_1/x4/Y 0
C808 ZMUX4_0/Zo_1 ZMUX4_0/Zo_0 0.00433f
C809 ZMUX4_0/y1 ZMUX4_0/y0 0.03527f
C810 ZMUX4_0/sky130_fd_sc_hd__mux4_1_1/a_1290_413# ZMUX4_0/Z0_1 0.00451f
C811 NLC_4bit_3/x1/a_475_297# A5 0
C812 NLC_4bit_2/a NLC_4bit_3/x3/a_199_47# 0
C813 A4 A8 0.27623f
C814 A9 NLC_4bit_0/x4/Y 0
C815 ZMUX4_0/Z0_0 ZMUX4_0/sky130_fd_sc_hd__mux4_1_0/a_834_97# 0.00107f
C816 NLC_4bit_1/x3/a_199_47# A7 -0
C817 A11 A5 0
C818 A2 BNE_4bit_0/x2/Y 0
C819 A11 A9 -0
C820 A13 ZMUX4_0/Z1_1 0.01496f
C821 ZMUX4_0/y1 ZMUX4_0/sky130_fd_sc_hd__mux4_1_0/a_750_97# -0.00189f
C822 ZMUX4_0/Z1_0 A1 0.01106f
C823 ZMUX4_0/Z2_0 NLC_4bit_1/a 0.00112f
C824 NLC_4bit_1/a ZMUX4_0/Z3_1 0
C825 ZMUX4_0/sky130_fd_sc_hd__mux4_1_1/a_757_363# ZMUX4_0/y0 0.00804f
C826 ZMUX4_0/y0 A5 0
C827 ZMUX4_0/Zo_1 ZMUX4_0/sky130_fd_sc_hd__mux4_1_0/a_668_97# 0.00339f
C828 ZMUX4_0/Zo_1 Y4 0
C829 ZMUX4_0/Z1_0 sky130_fd_sc_hd__inv_1_0/A 0.07051f
C830 A0 ZMUX4_0/Z0_1 0
C831 ZMUX4_0/Z2_1 BNE_4bit_0/x3/Y 0
C832 A13 A7 0
C833 sky130_fd_sc_hd__inv_1_1/Y sky130_fd_sc_hd__inv_1_0/A 0.0252f
C834 ZMUX4_0/sky130_fd_sc_hd__mux4_1_1/a_834_97# ZMUX4_0/Zo_0 0
C835 NLC_4bit_2/x1/a_281_297# ZMUX4_0/Z1_1 0.00112f
C836 ZMUX4_0/Z2_0 NLC_4bit_3/x4/Y 0
C837 ZMUX4_0/Z3_1 NLC_4bit_3/x4/Y 0
C838 ZMUX4_0/y1 ZMUX4_0/sky130_fd_sc_hd__mux4_1_0/a_247_21# -0.00178f
C839 BNE_4bit_0/x3/Y NLC_4bit_1/x1/a_281_297# 0
C840 sky130_fd_sc_hd__nand2_1_3/a_113_47# sky130_fd_sc_hd__inv_1_2/A 0
C841 BNE_4bit_0/x8/A sky130_fd_sc_hd__inv_1_2/A 0.00408f
C842 ZMUX4_0/Z2_0 ZMUX4_0/Zo_1 0
C843 ZMUX4_0/Zo_1 ZMUX4_0/Z3_1 0.00336f
C844 sky130_fd_sc_hd__inv_1_0/A NLC_4bit_0/x4/Y 0
C845 ZMUX4_0/Z0_1 sky130_fd_sc_hd__inv_1_3/A 0.01559f
C846 ZMUX4_0/sky130_fd_sc_hd__mux4_1_0/a_1290_413# ZMUX4_0/Z0_1 0.00391f
C847 ZMUX4_0/y1 Y1 0.01785f
C848 A11 A1 0
C849 ZMUX4_0/sky130_fd_sc_hd__mux4_1_0/a_1290_413# ZMUX4_0/sky130_fd_sc_hd__mux4_1_0/a_1478_413# -0.00204f
C850 ZMUX4_0/Z1_0 NLC_4bit_3/x3/a_199_47# 0
C851 ZMUX4_0/Z2_1 A10 0
C852 NLC_4bit_3/a ZMUX4_0/sky130_fd_sc_hd__mux4_1_0/a_277_47# 0
C853 Y4 NLC_4bit_0/a 0
C854 A12 NLC_4bit_1/a 0.00134f
C855 A1 ZMUX4_0/y0 0.00138f
C856 A10 NLC_4bit_1/x1/a_281_297# 0
C857 ZMUX4_0/Z2_1 ZMUX4_0/sky130_fd_sc_hd__mux4_1_0/a_834_97# 0
C858 NLC_4bit_0/x1/a_27_297# A1 0
C859 ZMUX4_0/sky130_fd_sc_hd__mux4_1_1/a_247_21# NLC_4bit_2/x4/Y 0
C860 ZMUX4_0/y0 sky130_fd_sc_hd__inv_1_0/A 0.00108f
C861 NLC_4bit_0/x1/a_27_297# sky130_fd_sc_hd__inv_1_0/A 0
C862 ZMUX4_0/sky130_fd_sc_hd__mux4_1_1/a_193_413# ZMUX4_0/Z0_1 0.00222f
C863 ZMUX4_0/y1 ZMUX4_0/sky130_fd_sc_hd__mux4_1_1/a_277_47# -0.00545f
C864 sky130_fd_sc_hd__inv_1_4/A ZMUX4_0/Zo_1 0
C865 A2 BNE_4bit_0/x3/Y 0
C866 NLC_4bit_3/a ZMUX4_0/Zo_0 0
C867 ZMUX4_0/Z2_0 ZMUX4_0/sky130_fd_sc_hd__mux4_1_1/a_834_97# 0
C868 ZMUX4_0/Z2_0 NLC_4bit_0/a 0
C869 A9 NLC_4bit_0/x3/a_113_297# 0
C870 NLC_4bit_3/x3/a_113_297# ZMUX4_0/Z1_0 0
C871 NLC_4bit_1/x3/a_113_297# NLC_4bit_2/x4/Y 0
C872 ZMUX4_0/y1 VDD 0.92834f
C873 ZMUX4_0/y1 ZMUX4_0/Z0_0 0.00973f
C874 ZMUX4_0/sky130_fd_sc_hd__mux4_1_1/a_668_97# ZMUX4_0/Zo_0 0
C875 ZMUX4_0/Z1_0 NLC_4bit_2/x3/a_199_47# 0
C876 A2 A10 0
C877 NLC_4bit_0/x1/a_281_297# BNE_4bit_0/x3/Y 0
C878 ZMUX4_0/Zo_1 ZMUX4_0/sky130_fd_sc_hd__mux4_1_0/a_27_413# 0
C879 NLC_4bit_3/a Y4 0.00174f
C880 ZMUX4_0/sky130_fd_sc_hd__mux4_1_1/a_1290_413# ZMUX4_0/Zo_0 0.02462f
C881 A9 ZMUX4_0/sky130_fd_sc_hd__mux4_1_1/a_277_47# 0
C882 ZMUX4_0/y1 Y2 0.00812f
C883 BNE_4bit_0/x8/a_27_297# Y4 0.00139f
C884 ZMUX4_0/y1 sky130_fd_sc_hd__nand2_1_0/a_113_47# 0
C885 NLC_4bit_1/x1/a_27_297# ZMUX4_0/Z1_1 -0
C886 A15 A5 0
C887 ZMUX4_0/sky130_fd_sc_hd__mux4_1_1/a_757_363# VDD -0
C888 ZMUX4_0/sky130_fd_sc_hd__mux4_1_1/a_757_363# ZMUX4_0/Z0_0 0.00422f
C889 A5 VDD 0.01678f
C890 A3 NLC_4bit_2/a 0.20868f
C891 A15 A9 0
C892 A5 ZMUX4_0/Z0_0 0
C893 NLC_4bit_2/x1/a_281_297# BNE_4bit_0/x3/Y 0
C894 NLC_4bit_3/x3/a_113_297# ZMUX4_0/y0 0
C895 ZMUX4_0/Z2_0 NLC_4bit_3/a 0.03064f
C896 NLC_4bit_3/a ZMUX4_0/Z3_1 0.04018f
C897 A9 VDD 0.013f
C898 NLC_4bit_0/x1/a_281_297# A10 0
C899 A9 ZMUX4_0/Z0_0 0
C900 NLC_4bit_1/a ZMUX4_0/Z3_0 0
C901 NLC_4bit_1/x2/a_109_297# ZMUX4_0/Z1_1 -0
C902 ZMUX4_0/sky130_fd_sc_hd__mux4_1_0/a_193_413# ZMUX4_0/Z3_1 0.00335f
C903 ZMUX4_0/sky130_fd_sc_hd__mux4_1_1/a_27_413# ZMUX4_0/Z1_1 0.00255f
C904 NLC_4bit_2/a BNE_4bit_0/x3/A 0
C905 sky130_fd_sc_hd__inv_1_4/A sky130_fd_sc_hd__nand2_1_2/a_113_47# 0
C906 NLC_4bit_3/a ZMUX4_0/sky130_fd_sc_hd__mux4_1_0/a_27_47# 0.00467f
C907 ZMUX4_0/Z3_0 NLC_4bit_3/x4/Y 0
C908 ZMUX4_0/Z2_0 ZMUX4_0/sky130_fd_sc_hd__mux4_1_1/a_668_97# 0
C909 ZMUX4_0/y1 ZMUX4_0/Z2_1 0.00132f
C910 A3 A6 0.00146f
C911 ZMUX4_0/sky130_fd_sc_hd__mux4_1_1/a_247_21# ZMUX4_0/Z1_1 0.00432f
C912 NLC_4bit_3/x3/a_113_297# ZMUX4_0/sky130_fd_sc_hd__mux4_1_0/a_750_97# 0
C913 ZMUX4_0/Zo_1 ZMUX4_0/Z3_0 0
C914 NLC_4bit_1/x4/Y NLC_4bit_2/x4/Y 0.00455f
C915 ZMUX4_0/Z2_0 ZMUX4_0/sky130_fd_sc_hd__mux4_1_1/a_1290_413# 0
C916 ZMUX4_0/Zo_0 sky130_fd_sc_hd__inv_1_3/A 0.00102f
C917 ZMUX4_0/y1 NLC_4bit_1/x1/a_281_297# 0
C918 ZMUX4_0/sky130_fd_sc_hd__mux4_1_0/a_1290_413# ZMUX4_0/Zo_0 0
C919 A1 VDD 0.01727f
C920 ZMUX4_0/sky130_fd_sc_hd__mux4_1_1/a_750_97# ZMUX4_0/Z0_1 0.0132f
C921 ZMUX4_0/sky130_fd_sc_hd__mux4_1_0/a_923_363# ZMUX4_0/Z1_1 0
C922 A1 ZMUX4_0/Z0_0 0.02358f
C923 BNE_4bit_0/x3/A A6 0
C924 ZMUX4_0/y1 ZMUX4_0/sky130_fd_sc_hd__mux4_1_1/a_27_47# 0
C925 NLC_4bit_2/a NLC_4bit_1/a 0.7502f
C926 sky130_fd_sc_hd__inv_1_0/A VDD 0.01976f
C927 Y3 ZMUX4_0/sky130_fd_sc_hd__mux4_1_1/a_247_21# 0
C928 A12 NLC_4bit_3/a 0
C929 ZMUX4_0/Z0_0 sky130_fd_sc_hd__inv_1_0/A 0.21173f
C930 ZMUX4_0/y1 sky130_fd_sc_hd__inv_1_2/A 0.02514f
C931 NLC_4bit_3/x3/a_113_297# ZMUX4_0/sky130_fd_sc_hd__mux4_1_0/a_247_21# 0
C932 NLC_4bit_1/x3/a_113_297# ZMUX4_0/Z1_1 0.00421f
C933 ZMUX4_0/Z2_1 ZMUX4_0/sky130_fd_sc_hd__mux4_1_1/a_757_363# 0
C934 A12 ZMUX4_0/sky130_fd_sc_hd__mux4_1_0/a_193_413# 0
C935 A3 ZMUX4_0/Z1_0 0.01017f
C936 NLC_4bit_2/a NLC_4bit_3/x4/Y 0.00145f
C937 ZMUX4_0/Z2_1 A5 0
C938 ZMUX4_0/Z1_1 NLC_4bit_2/x4/Y 0.00812f
C939 ZMUX4_0/sky130_fd_sc_hd__mux4_1_1/a_247_21# NLC_4bit_2/x1/a_475_297# 0
C940 Y2 sky130_fd_sc_hd__inv_1_0/A 0
C941 sky130_fd_sc_hd__nand2_1_0/a_113_47# sky130_fd_sc_hd__inv_1_0/A 0
C942 ZMUX4_0/Z2_1 A9 0.01957f
C943 A15 NLC_4bit_3/x3/a_199_47# 0
C944 sky130_fd_sc_hd__inv_1_3/A Y4 0
C945 NLC_4bit_3/x1/a_281_297# ZMUX4_0/Z1_1 0.0011f
C946 NLC_4bit_2/a ZMUX4_0/Zo_1 0
C947 sky130_fd_sc_hd__inv_1_4/A ZMUX4_0/sky130_fd_sc_hd__mux4_1_1/a_1290_413# 0
C948 ZMUX4_0/sky130_fd_sc_hd__mux4_1_1/a_834_97# ZMUX4_0/Z3_0 0
C949 ZMUX4_0/y1 BNE_4bit_0/x8/B 0.00167f
C950 A7 NLC_4bit_2/x4/Y 0
C951 NLC_4bit_3/a ZMUX4_0/sky130_fd_sc_hd__mux4_1_0/a_27_413# 0
C952 NLC_4bit_1/a A6 0.04981f
C953 A3 NLC_4bit_0/x4/Y 0
C954 A9 NLC_4bit_1/x1/a_281_297# 0
C955 A8 ZMUX4_0/Z0_1 0
C956 NLC_4bit_2/x3/a_113_297# A5 0
C957 NLC_4bit_2/a NLC_4bit_0/x1/a_475_297# 0.00483f
C958 A5 sky130_fd_sc_hd__inv_1_2/A 0
C959 ZMUX4_0/sky130_fd_sc_hd__mux4_1_1/a_923_363# ZMUX4_0/y0 0
C960 A6 NLC_4bit_3/x4/Y 0
C961 A11 A3 0
C962 ZMUX4_0/sky130_fd_sc_hd__mux4_1_0/a_1290_413# ZMUX4_0/Z3_1 0
C963 BNE_4bit_0/x3/A NLC_4bit_0/x4/Y 0
C964 sky130_fd_sc_hd__nand2_1_1/a_113_47# ZMUX4_0/Z0_1 0
C965 ZMUX4_0/sky130_fd_sc_hd__mux4_1_1/a_757_363# BNE_4bit_0/x8/B 0
C966 A11 BNE_4bit_0/x3/A 0
C967 A3 ZMUX4_0/y0 0.00207f
C968 ZMUX4_0/Z1_0 NLC_4bit_1/a -0.04341f
C969 NLC_4bit_2/a NLC_4bit_0/a 0.15941f
C970 ZMUX4_0/sky130_fd_sc_hd__mux4_1_1/a_277_47# NLC_4bit_2/x3/a_199_47# 0
C971 sky130_fd_sc_hd__inv_1_1/Y NLC_4bit_1/a 0
C972 ZMUX4_0/Z2_1 sky130_fd_sc_hd__inv_1_0/A 0
C973 NLC_4bit_3/x3/a_113_297# VDD -0
C974 NLC_4bit_2/x1/a_27_297# NLC_4bit_1/a 0.0013f
C975 ZMUX4_0/Z1_0 NLC_4bit_3/x4/Y 0
C976 NLC_4bit_0/x1/a_27_297# BNE_4bit_0/x3/A 0
C977 NLC_4bit_1/x1/a_27_297# A10 0
C978 NLC_4bit_1/a NLC_4bit_3/x1/a_475_297# 0
C979 A1 sky130_fd_sc_hd__inv_1_2/A 0
C980 A4 ZMUX4_0/Z3_1 0
C981 sky130_fd_sc_hd__inv_1_4/A sky130_fd_sc_hd__inv_1_3/A 0.02078f
C982 sky130_fd_sc_hd__inv_1_4/A ZMUX4_0/sky130_fd_sc_hd__mux4_1_0/a_1290_413# 0
C983 NLC_4bit_1/a NLC_4bit_0/x4/Y 0.01728f
C984 NLC_4bit_3/a ZMUX4_0/Z3_0 0.121f
C985 ZMUX4_0/sky130_fd_sc_hd__mux4_1_1/a_27_47# sky130_fd_sc_hd__inv_1_0/A 0
C986 ZMUX4_0/Z1_0 ZMUX4_0/Zo_1 0.14174f
C987 NLC_4bit_1/x4/Y ZMUX4_0/Z1_1 0
C988 sky130_fd_sc_hd__inv_1_0/A sky130_fd_sc_hd__inv_1_2/A 0.0132f
C989 ZMUX4_0/sky130_fd_sc_hd__mux4_1_0/a_193_413# ZMUX4_0/Z3_0 0
C990 sky130_fd_sc_hd__inv_1_1/Y ZMUX4_0/Zo_1 0.09526f
C991 A11 NLC_4bit_1/a 0.00258f
C992 NLC_4bit_1/x4/Y A7 -0
C993 ZMUX4_0/Z1_0 NLC_4bit_0/x1/a_475_297# 0
C994 A6 NLC_4bit_0/a 0
C995 ZMUX4_0/sky130_fd_sc_hd__mux4_1_0/a_757_363# ZMUX4_0/Z0_1 0.00293f
C996 BNE_4bit_0/x4/a_285_47# NLC_4bit_1/a 0
C997 ZMUX4_0/sky130_fd_sc_hd__mux4_1_1/a_668_97# ZMUX4_0/Z3_0 0
C998 A11 NLC_4bit_3/x4/Y 0.00721f
C999 NLC_4bit_1/a ZMUX4_0/y0 0.00302f
C1000 NLC_4bit_0/x1/a_27_297# NLC_4bit_1/a 0.00729f
C1001 A1 A2 0.02273f
C1002 sky130_fd_sc_hd__inv_1_0/A BNE_4bit_0/x8/B 0
C1003 A13 A5 0
C1004 NLC_4bit_2/a NLC_4bit_0/x3/a_199_47# 0
C1005 NLC_4bit_2/a NLC_4bit_3/a 0.44955f
C1006 ZMUX4_0/sky130_fd_sc_hd__mux4_1_1/a_750_97# ZMUX4_0/Zo_0 0.00971f
C1007 NLC_4bit_1/x4/Y BNE_4bit_0/x2/Y 0
C1008 A13 A9 0.01631f
C1009 ZMUX4_0/sky130_fd_sc_hd__mux4_1_0/a_1478_413# ZMUX4_0/Z0_1 0.00289f
C1010 ZMUX4_0/y0 NLC_4bit_3/x4/Y 0
C1011 A7 ZMUX4_0/Z1_1 0
C1012 ZMUX4_0/sky130_fd_sc_hd__mux4_1_1/a_834_97# ZMUX4_0/Z1_0 0.00621f
C1013 ZMUX4_0/Z1_0 NLC_4bit_0/a 0.07947f
C1014 NLC_4bit_2/x1/a_281_297# A5 0
C1015 A12 A4 0
C1016 NLC_4bit_3/x3/a_113_297# ZMUX4_0/Z2_1 0.00147f
C1017 ZMUX4_0/Zo_1 ZMUX4_0/y0 0.28697f
C1018 NLC_4bit_1/x1/a_475_297# ZMUX4_0/Z1_1 0
C1019 NLC_4bit_0/x1/a_475_297# ZMUX4_0/y0 0.00116f
C1020 NLC_4bit_1/x3/a_199_47# sky130_fd_sc_hd__inv_1_0/A 0
C1021 NLC_4bit_0/x4/Y NLC_4bit_0/a 0.00427f
C1022 NLC_4bit_2/x1/a_475_297# ZMUX4_0/Z1_1 0.00247f
C1023 NLC_4bit_1/x1/a_475_297# A7 -0
C1024 ZMUX4_0/sky130_fd_sc_hd__mux4_1_1/a_923_363# VDD -0
C1025 BNE_4bit_0/x2/Y ZMUX4_0/Z1_1 0
C1026 NLC_4bit_3/a A6 0
C1027 ZMUX4_0/sky130_fd_sc_hd__mux4_1_1/a_923_363# ZMUX4_0/Z0_0 0
C1028 A11 NLC_4bit_0/a 0
C1029 BNE_4bit_0/x2/Y A7 0
C1030 A7 NLC_4bit_2/x1/a_475_297# 0
C1031 ZMUX4_0/Z1_0 sky130_fd_sc_hd__nand2_1_2/a_113_47# 0
C1032 ZMUX4_0/Zo_1 ZMUX4_0/sky130_fd_sc_hd__mux4_1_0/a_750_97# 0.0561f
C1033 NLC_4bit_1/a NLC_4bit_0/x3/a_113_297# 0
C1034 sky130_fd_sc_hd__inv_1_1/Y sky130_fd_sc_hd__nand2_1_2/a_113_47# 0
C1035 BNE_4bit_0/x4/a_285_47# NLC_4bit_0/a 0
C1036 A3 VDD 0.02024f
C1037 ZMUX4_0/sky130_fd_sc_hd__mux4_1_0/a_247_21# NLC_4bit_3/x4/Y 0
C1038 A3 ZMUX4_0/Z0_0 0
C1039 ZMUX4_0/y0 NLC_4bit_0/a 0.09721f
C1040 ZMUX4_0/sky130_fd_sc_hd__mux4_1_0/a_1290_413# ZMUX4_0/Z3_0 0
C1041 ZMUX4_0/sky130_fd_sc_hd__mux4_1_1/a_834_97# ZMUX4_0/y0 -0.00153f
C1042 ZMUX4_0/Z2_0 ZMUX4_0/sky130_fd_sc_hd__mux4_1_1/a_750_97# 0
C1043 NLC_4bit_1/x1/a_475_297# BNE_4bit_0/x2/Y 0
C1044 ZMUX4_0/Z1_0 NLC_4bit_0/x3/a_199_47# 0
C1045 A14 NLC_4bit_1/a 0.00114f
C1046 ZMUX4_0/Z1_0 NLC_4bit_3/a 0.10648f
C1047 ZMUX4_0/Zo_1 ZMUX4_0/sky130_fd_sc_hd__mux4_1_0/a_247_21# 0.00368f
C1048 BNE_4bit_0/x3/A VDD 0.00412f
C1049 sky130_fd_sc_hd__inv_1_1/Y NLC_4bit_3/a 0.00529f
C1050 ZMUX4_0/y1 NLC_4bit_1/x1/a_27_297# 0
C1051 BNE_4bit_0/x2/Y NLC_4bit_2/x1/a_475_297# 0
C1052 NLC_4bit_2/a A0 0.26579f
C1053 sky130_fd_sc_hd__inv_1_1/Y BNE_4bit_0/x8/a_27_297# 0
C1054 NLC_4bit_1/x4/Y BNE_4bit_0/x3/Y 0
C1055 sky130_fd_sc_hd__inv_1_1/Y ZMUX4_0/sky130_fd_sc_hd__mux4_1_0/a_193_413# 0
C1056 NLC_4bit_3/a NLC_4bit_0/x4/Y 0.00179f
C1057 ZMUX4_0/sky130_fd_sc_hd__mux4_1_1/a_193_413# ZMUX4_0/Z3_0 0.00229f
C1058 sky130_fd_sc_hd__nand2_1_2/a_113_47# ZMUX4_0/y0 0
C1059 ZMUX4_0/y1 ZMUX4_0/sky130_fd_sc_hd__mux4_1_1/a_27_413# 0
C1060 A15 NLC_4bit_1/a 0
C1061 A11 NLC_4bit_3/a 0.00915f
C1062 ZMUX4_0/Z2_0 A8 0
C1063 ZMUX4_0/Z2_1 ZMUX4_0/sky130_fd_sc_hd__mux4_1_1/a_923_363# 0
C1064 ZMUX4_0/Z1_0 ZMUX4_0/sky130_fd_sc_hd__mux4_1_1/a_1290_413# 0.02832f
C1065 NLC_4bit_1/a VDD 0.17841f
C1066 NLC_4bit_1/a ZMUX4_0/Z0_0 0
C1067 NLC_4bit_1/x4/Y A10 0
C1068 sky130_fd_sc_hd__inv_1_1/Y ZMUX4_0/sky130_fd_sc_hd__mux4_1_1/a_1290_413# 0
C1069 ZMUX4_0/Z0_1 ZMUX4_0/sky130_fd_sc_hd__mux4_1_0/a_277_47# 0.02012f
C1070 BNE_4bit_0/x3/Y ZMUX4_0/Z1_1 0
C1071 ZMUX4_0/Zo_1 ZMUX4_0/sky130_fd_sc_hd__mux4_1_1/a_277_47# 0.00738f
C1072 A15 NLC_4bit_3/x4/Y 0
C1073 NLC_4bit_0/a NLC_4bit_0/x3/a_113_297# 0.00836f
C1074 ZMUX4_0/y1 ZMUX4_0/sky130_fd_sc_hd__mux4_1_1/a_247_21# -0.00119f
C1075 NLC_4bit_3/a ZMUX4_0/y0 0.04158f
C1076 BNE_4bit_0/x3/Y A7 0
C1077 BNE_4bit_0/x8/A Y3 0
C1078 VDD NLC_4bit_3/x4/Y 0
C1079 BNE_4bit_0/x8/a_27_297# ZMUX4_0/y0 0.00482f
C1080 sky130_fd_sc_hd__nand2_1_0/a_113_47# NLC_4bit_1/a 0
C1081 ZMUX4_0/y1 BNE_4bit_0/x7/a_113_47# -0
C1082 ZMUX4_0/Zo_1 VDD 0.25262f
C1083 NLC_4bit_2/a A4 0.00861f
C1084 ZMUX4_0/Zo_1 ZMUX4_0/Z0_0 0.09617f
C1085 ZMUX4_0/Z0_1 ZMUX4_0/Zo_0 0.00397f
C1086 NLC_4bit_1/x1/a_475_297# BNE_4bit_0/x3/Y 0
C1087 ZMUX4_0/sky130_fd_sc_hd__mux4_1_0/a_1478_413# ZMUX4_0/Zo_0 0.0022f
C1088 ZMUX4_0/Z1_0 A0 0
C1089 A10 ZMUX4_0/Z1_1 0.00259f
C1090 ZMUX4_0/sky130_fd_sc_hd__mux4_1_1/a_668_97# ZMUX4_0/y0 -0
C1091 ZMUX4_0/y1 NLC_4bit_1/x3/a_113_297# 0.00222f
C1092 NLC_4bit_0/x1/a_475_297# VDD -0
C1093 NLC_4bit_0/x1/a_475_297# ZMUX4_0/Z0_0 0
C1094 BNE_4bit_0/x3/Y NLC_4bit_2/x1/a_475_297# 0
C1095 NLC_4bit_3/a ZMUX4_0/sky130_fd_sc_hd__mux4_1_0/a_750_97# 0
C1096 A7 A10 0
C1097 A12 A8 0.01026f
C1098 ZMUX4_0/sky130_fd_sc_hd__mux4_1_1/a_1290_413# ZMUX4_0/y0 -0
C1099 ZMUX4_0/sky130_fd_sc_hd__mux4_1_0/a_834_97# ZMUX4_0/Z1_1 0.00402f
C1100 ZMUX4_0/Zo_1 Y2 0
C1101 A9 ZMUX4_0/sky130_fd_sc_hd__mux4_1_1/a_247_21# 0
C1102 ZMUX4_0/Z1_0 ZMUX4_0/sky130_fd_sc_hd__mux4_1_0/a_1290_413# 0.00349f
C1103 ZMUX4_0/Z1_0 sky130_fd_sc_hd__inv_1_3/A 0.02313f
C1104 A0 NLC_4bit_0/x4/Y -0
C1105 sky130_fd_sc_hd__inv_1_1/Y sky130_fd_sc_hd__inv_1_3/A 0.06496f
C1106 A4 A6 -0
C1107 NLC_4bit_3/a ZMUX4_0/sky130_fd_sc_hd__mux4_1_0/a_247_21# 0.00238f
C1108 ZMUX4_0/sky130_fd_sc_hd__mux4_1_0/a_668_97# ZMUX4_0/Z0_1 0.00532f
C1109 ZMUX4_0/Z0_1 Y4 0.00196f
C1110 A11 A0 0
C1111 ZMUX4_0/Z3_1 ZMUX4_0/sky130_fd_sc_hd__mux4_1_0/a_757_363# 0
C1112 NLC_4bit_3/a NLC_4bit_0/x3/a_113_297# 0.00698f
C1113 ZMUX4_0/Z2_1 NLC_4bit_1/a 0.00361f
C1114 VDD NLC_4bit_0/a 0.13028f
C1115 ZMUX4_0/y1 ZMUX4_0/sky130_fd_sc_hd__mux4_1_1/a_1478_413# -0.00341f
C1116 ZMUX4_0/Z0_0 NLC_4bit_0/a 0.01196f
C1117 ZMUX4_0/sky130_fd_sc_hd__mux4_1_1/a_834_97# ZMUX4_0/Z0_0 0.00567f
C1118 BNE_4bit_0/x2/Y A10 0
C1119 Y1 NLC_4bit_3/a 0
C1120 A3 A2 0.02479f
C1121 ZMUX4_0/sky130_fd_sc_hd__mux4_1_1/a_27_413# sky130_fd_sc_hd__inv_1_0/A 0
C1122 NLC_4bit_1/a NLC_4bit_1/x1/a_281_297# 0.00295f
C1123 A9 NLC_4bit_1/x3/a_113_297# 0
C1124 ZMUX4_0/sky130_fd_sc_hd__mux4_1_1/a_193_413# ZMUX4_0/Z1_0 0
C1125 A0 ZMUX4_0/y0 0
C1126 A5 NLC_4bit_2/x4/Y 0
C1127 ZMUX4_0/Z2_1 NLC_4bit_3/x4/Y 0.00124f
C1128 A5 NLC_4bit_3/x1/a_281_297# 0
C1129 ZMUX4_0/sky130_fd_sc_hd__mux4_1_1/a_750_97# ZMUX4_0/Z3_0 0
C1130 A14 NLC_4bit_3/a 0
C1131 NLC_4bit_1/a NLC_4bit_2/x3/a_113_297# 0.00171f
C1132 ZMUX4_0/Z2_0 ZMUX4_0/Z0_1 0
C1133 ZMUX4_0/Z3_1 ZMUX4_0/Z0_1 0.00143f
C1134 Y2 NLC_4bit_0/a 0
C1135 sky130_fd_sc_hd__inv_1_1/Y ZMUX4_0/sky130_fd_sc_hd__mux4_1_1/a_193_413# 0
C1136 ZMUX4_0/Z3_1 ZMUX4_0/sky130_fd_sc_hd__mux4_1_0/a_1478_413# 0
C1137 A2 BNE_4bit_0/x3/A 0
C1138 ZMUX4_0/Z1_0 A4 0
C1139 NLC_4bit_1/a sky130_fd_sc_hd__inv_1_2/A 0
C1140 ZMUX4_0/Z2_1 ZMUX4_0/Zo_1 0
C1141 ZMUX4_0/sky130_fd_sc_hd__mux4_1_1/a_247_21# sky130_fd_sc_hd__inv_1_0/A 0
C1142 Y0 sky130_fd_sc_hd__inv_1_3/A 0
C1143 A4 NLC_4bit_2/x1/a_27_297# 0
C1144 NLC_4bit_3/a ZMUX4_0/sky130_fd_sc_hd__mux4_1_1/a_277_47# 0
C1145 ZMUX4_0/y0 sky130_fd_sc_hd__inv_1_3/A 0.18102f
C1146 sky130_fd_sc_hd__nand2_1_2/a_113_47# VDD -0
C1147 ZMUX4_0/sky130_fd_sc_hd__mux4_1_0/a_1290_413# ZMUX4_0/y0 -0
C1148 ZMUX4_0/sky130_fd_sc_hd__mux4_1_0/a_27_47# ZMUX4_0/Z0_1 0.00108f
C1149 A4 NLC_4bit_3/x1/a_475_297# 0
C1150 Y1 ZMUX4_0/sky130_fd_sc_hd__mux4_1_1/a_1290_413# 0
C1151 A12 ZMUX4_0/sky130_fd_sc_hd__mux4_1_0/a_757_363# 0
C1152 ZMUX4_0/y1 NLC_4bit_1/x4/Y 0
C1153 ZMUX4_0/Zo_1 sky130_fd_sc_hd__inv_1_2/A 0
C1154 A15 NLC_4bit_3/a 0.00461f
C1155 A11 A4 0.00106f
C1156 sky130_fd_sc_hd__inv_1_4/A ZMUX4_0/Z0_1 0.00396f
C1157 A2 NLC_4bit_1/a 0.0508f
C1158 NLC_4bit_2/a ZMUX4_0/sky130_fd_sc_hd__mux4_1_1/a_750_97# 0
C1159 NLC_4bit_3/a VDD 0.17638f
C1160 NLC_4bit_3/a ZMUX4_0/Z0_0 0.21813f
C1161 BNE_4bit_0/x8/a_27_297# VDD 0
C1162 sky130_fd_sc_hd__inv_1_4/A ZMUX4_0/sky130_fd_sc_hd__mux4_1_0/a_1478_413# 0
C1163 BNE_4bit_0/x8/a_27_297# ZMUX4_0/Z0_0 0
C1164 ZMUX4_0/sky130_fd_sc_hd__mux4_1_1/a_834_97# ZMUX4_0/Z2_1 0
C1165 ZMUX4_0/sky130_fd_sc_hd__mux4_1_1/a_193_413# ZMUX4_0/y0 0.00225f
C1166 ZMUX4_0/Zo_0 ZMUX4_0/sky130_fd_sc_hd__mux4_1_0/a_277_47# 0
C1167 ZMUX4_0/sky130_fd_sc_hd__mux4_1_0/a_1290_413# ZMUX4_0/sky130_fd_sc_hd__mux4_1_0/a_750_97# -0.00187f
C1168 ZMUX4_0/sky130_fd_sc_hd__mux4_1_0/a_193_413# VDD -0
C1169 ZMUX4_0/Z2_1 NLC_4bit_0/a 0
C1170 ZMUX4_0/sky130_fd_sc_hd__mux4_1_0/a_193_413# ZMUX4_0/Z0_0 0.00124f
C1171 A0 NLC_4bit_0/x3/a_113_297# -0
C1172 NLC_4bit_3/a Y2 0
C1173 ZMUX4_0/y1 ZMUX4_0/Z1_1 0.08599f
C1174 sky130_fd_sc_hd__nand2_1_0/a_113_47# NLC_4bit_3/a 0
C1175 ZMUX4_0/sky130_fd_sc_hd__mux4_1_1/a_668_97# VDD -0
C1176 NLC_4bit_1/x3/a_199_47# NLC_4bit_1/a -0
C1177 ZMUX4_0/sky130_fd_sc_hd__mux4_1_1/a_668_97# ZMUX4_0/Z0_0 0.00988f
C1178 NLC_4bit_1/x4/Y A5 -0
C1179 NLC_4bit_2/x3/a_113_297# NLC_4bit_0/a 0
C1180 ZMUX4_0/sky130_fd_sc_hd__mux4_1_0/a_1290_413# ZMUX4_0/sky130_fd_sc_hd__mux4_1_0/a_247_21# -0
C1181 ZMUX4_0/y1 A7 0
C1182 sky130_fd_sc_hd__inv_1_2/A NLC_4bit_0/a 0
C1183 NLC_4bit_1/a NLC_4bit_0/x1/a_281_297# 0.00286f
C1184 NLC_4bit_1/x4/Y A9 0
C1185 ZMUX4_0/sky130_fd_sc_hd__mux4_1_1/a_1290_413# VDD 0.00571f
C1186 ZMUX4_0/y1 Y3 0.00708f
C1187 ZMUX4_0/sky130_fd_sc_hd__mux4_1_1/a_1290_413# ZMUX4_0/Z0_0 0
C1188 NLC_4bit_2/a A8 0.0085f
C1189 Y1 sky130_fd_sc_hd__inv_1_3/A 0.01785f
C1190 A13 NLC_4bit_1/a 0.0019f
C1191 NLC_4bit_1/x1/a_475_297# ZMUX4_0/y1 0
C1192 ZMUX4_0/sky130_fd_sc_hd__mux4_1_1/a_757_363# ZMUX4_0/Z1_1 0
C1193 A5 ZMUX4_0/Z1_1 0.00331f
C1194 NLC_4bit_2/x1/a_281_297# NLC_4bit_1/a 0.00197f
C1195 ZMUX4_0/sky130_fd_sc_hd__mux4_1_1/a_1290_413# Y2 0
C1196 NLC_4bit_0/a BNE_4bit_0/x8/B 0.0033f
C1197 ZMUX4_0/y1 BNE_4bit_0/x2/Y -0
C1198 A9 ZMUX4_0/Z1_1 0.01546f
C1199 ZMUX4_0/Z1_0 ZMUX4_0/sky130_fd_sc_hd__mux4_1_1/a_750_97# 0.03886f
C1200 A5 A7 -0.00119f
C1201 ZMUX4_0/Z3_1 ZMUX4_0/sky130_fd_sc_hd__mux4_1_0/a_277_47# 0.00327f
C1202 A2 NLC_4bit_0/a 0.00561f
C1203 sky130_fd_sc_hd__inv_1_1/Y ZMUX4_0/sky130_fd_sc_hd__mux4_1_1/a_750_97# 0
C1204 ZMUX4_0/Z2_1 NLC_4bit_3/a 0.18313f
C1205 ZMUX4_0/sky130_fd_sc_hd__mux4_1_1/a_277_47# sky130_fd_sc_hd__inv_1_3/A 0
C1206 sky130_fd_sc_hd__nand2_1_2/a_113_47# sky130_fd_sc_hd__inv_1_2/A 0
C1207 A1 NLC_4bit_1/x4/Y 0
C1208 A0 VDD 0.05896f
C1209 ZMUX4_0/Zo_0 Y4 0
C1210 A8 A6 0
C1211 A9 A7 0
C1212 A0 ZMUX4_0/Z0_0 0
C1213 ZMUX4_0/Z2_1 ZMUX4_0/sky130_fd_sc_hd__mux4_1_0/a_193_413# 0
C1214 NLC_4bit_1/x4/Y sky130_fd_sc_hd__inv_1_0/A 0.0016f
C1215 NLC_4bit_3/a ZMUX4_0/sky130_fd_sc_hd__mux4_1_1/a_27_47# 0.00331f
C1216 ZMUX4_0/sky130_fd_sc_hd__mux4_1_0/a_27_47# ZMUX4_0/sky130_fd_sc_hd__mux4_1_0/a_277_47# -0.00177f
C1217 ZMUX4_0/Z2_1 ZMUX4_0/sky130_fd_sc_hd__mux4_1_1/a_668_97# 0
C1218 NLC_4bit_3/a sky130_fd_sc_hd__inv_1_2/A 0
C1219 NLC_4bit_1/x3/a_199_47# NLC_4bit_0/a 0
C1220 NLC_4bit_1/x1/a_475_297# A9 0
C1221 ZMUX4_0/Z2_0 ZMUX4_0/Zo_0 0
C1222 sky130_fd_sc_hd__inv_1_3/A VDD 0.02164f
C1223 ZMUX4_0/Z3_0 ZMUX4_0/Z0_1 0.04353f
C1224 ZMUX4_0/sky130_fd_sc_hd__mux4_1_0/a_1290_413# VDD -0.01897f
C1225 Y2 A0 0
C1226 BNE_4bit_0/x2/Y A5 0
C1227 BNE_4bit_0/x8/a_27_297# sky130_fd_sc_hd__inv_1_2/A 0
C1228 A5 NLC_4bit_2/x1/a_475_297# 0
C1229 ZMUX4_0/Z0_0 sky130_fd_sc_hd__inv_1_3/A 0
C1230 NLC_4bit_0/x1/a_281_297# NLC_4bit_0/a 0.00134f
C1231 A9 BNE_4bit_0/x2/Y 0
C1232 ZMUX4_0/Z2_1 ZMUX4_0/sky130_fd_sc_hd__mux4_1_1/a_1290_413# 0
C1233 A9 BNE_4bit_0/x4/a_27_297# 0
C1234 sky130_fd_sc_hd__inv_1_0/A ZMUX4_0/Z1_1 0.00111f
C1235 A1 A7 0
C1236 A12 ZMUX4_0/sky130_fd_sc_hd__mux4_1_0/a_277_47# 0
C1237 ZMUX4_0/sky130_fd_sc_hd__mux4_1_1/a_750_97# ZMUX4_0/y0 0.00499f
C1238 Y2 sky130_fd_sc_hd__inv_1_3/A 0.05011f
C1239 sky130_fd_sc_hd__nand2_1_0/a_113_47# sky130_fd_sc_hd__inv_1_3/A 0
C1240 NLC_4bit_3/a BNE_4bit_0/x8/B 0.013f
C1241 NLC_4bit_1/x1/a_27_297# BNE_4bit_0/x3/A 0
C1242 A1 Y3 0.00158f
C1243 ZMUX4_0/sky130_fd_sc_hd__mux4_1_1/a_193_413# VDD -0
C1244 A2 NLC_4bit_3/a 0.00187f
C1245 ZMUX4_0/y1 BNE_4bit_0/x8/A 0
C1246 ZMUX4_0/sky130_fd_sc_hd__mux4_1_1/a_193_413# ZMUX4_0/Z0_0 0.00894f
C1247 A15 A4 0
C1248 A8 NLC_4bit_0/x4/Y 0
C1249 Y3 sky130_fd_sc_hd__inv_1_0/A 0.01689f
C1250 ZMUX4_0/Z1_0 sky130_fd_sc_hd__nand2_1_1/a_113_47# 0
C1251 A4 VDD 0.05295f
C1252 sky130_fd_sc_hd__inv_1_1/Y sky130_fd_sc_hd__nand2_1_1/a_113_47# 0
C1253 ZMUX4_0/y1 BNE_4bit_0/x3/Y -0
C1254 sky130_fd_sc_hd__inv_1_4/A ZMUX4_0/Zo_0 0.02493f
C1255 NLC_4bit_2/a ZMUX4_0/Z0_1 0.00841f
C1256 NLC_4bit_3/x3/a_199_47# ZMUX4_0/Z1_1 0
C1257 A1 BNE_4bit_0/x2/Y 0
C1258 A1 BNE_4bit_0/x4/a_27_297# 0
C1259 NLC_4bit_3/x3/a_113_297# NLC_4bit_1/x4/Y 0
C1260 NLC_4bit_1/x3/a_199_47# NLC_4bit_3/a 0
C1261 ZMUX4_0/Z2_0 ZMUX4_0/Z3_1 0
C1262 NLC_4bit_1/x1/a_27_297# NLC_4bit_1/a 0.00285f
C1263 A8 ZMUX4_0/y0 0
C1264 ZMUX4_0/sky130_fd_sc_hd__mux4_1_0/a_1290_413# ZMUX4_0/Z2_1 0
C1265 A0 sky130_fd_sc_hd__inv_1_2/A 0
C1266 NLC_4bit_3/x1/a_27_297# A6 0
C1267 sky130_fd_sc_hd__inv_1_4/A Y4 0.00621f
C1268 BNE_4bit_0/x3/Y A5 0
C1269 ZMUX4_0/sky130_fd_sc_hd__mux4_1_0/a_27_47# ZMUX4_0/Z3_1 0
C1270 A13 NLC_4bit_3/a 0.00117f
C1271 ZMUX4_0/y1 ZMUX4_0/sky130_fd_sc_hd__mux4_1_0/a_834_97# -0
C1272 ZMUX4_0/Z1_0 ZMUX4_0/sky130_fd_sc_hd__mux4_1_0/a_757_363# 0
C1273 sky130_fd_sc_hd__nand2_1_1/a_113_47# ZMUX4_0/y0 0
C1274 NLC_4bit_3/x3/a_113_297# ZMUX4_0/Z1_1 0.00676f
C1275 A9 BNE_4bit_0/x3/Y 0
C1276 NLC_4bit_1/a NLC_4bit_1/x2/a_109_297# 0
C1277 sky130_fd_sc_hd__inv_1_3/A sky130_fd_sc_hd__inv_1_2/A 0.01889f
C1278 ZMUX4_0/sky130_fd_sc_hd__mux4_1_1/a_193_413# ZMUX4_0/Z2_1 0
C1279 ZMUX4_0/Z1_0 ZMUX4_0/Z0_1 0.15865f
C1280 A5 A10 0
C1281 ZMUX4_0/Z2_1 A4 0
C1282 ZMUX4_0/Z3_0 ZMUX4_0/sky130_fd_sc_hd__mux4_1_0/a_277_47# 0.00119f
C1283 ZMUX4_0/Z1_0 ZMUX4_0/sky130_fd_sc_hd__mux4_1_0/a_1478_413# 0
C1284 A12 ZMUX4_0/Z3_1 0.006f
C1285 NLC_4bit_2/x3/a_199_47# ZMUX4_0/Z1_1 0
C1286 sky130_fd_sc_hd__inv_1_1/Y ZMUX4_0/Z0_1 0.02067f
C1287 A1 BNE_4bit_0/x8/A 0
C1288 A9 A10 0.02273f
C1289 ZMUX4_0/sky130_fd_sc_hd__mux4_1_1/a_277_47# ZMUX4_0/sky130_fd_sc_hd__mux4_1_1/a_750_97# -0.00935f
C1290 A4 NLC_4bit_1/x1/a_281_297# -0
C1291 A1 BNE_4bit_0/x3/Y 0.00769f
C1292 NLC_4bit_1/a BNE_4bit_0/x7/a_113_47# 0
C1293 ZMUX4_0/Z0_1 NLC_4bit_0/x4/Y 0
C1294 ZMUX4_0/Z3_0 ZMUX4_0/Zo_0 0
C1295 NLC_4bit_1/a NLC_4bit_1/x3/a_113_297# -0
C1296 ZMUX4_0/sky130_fd_sc_hd__mux4_1_0/a_757_363# ZMUX4_0/y0 0
C1297 ZMUX4_0/Zo_1 ZMUX4_0/sky130_fd_sc_hd__mux4_1_1/a_247_21# 0
C1298 ZMUX4_0/Z3_1 ZMUX4_0/sky130_fd_sc_hd__mux4_1_0/a_27_413# 0.0132f
C1299 A11 ZMUX4_0/Z0_1 0
C1300 ZMUX4_0/sky130_fd_sc_hd__mux4_1_1/a_750_97# VDD -0.00453f
C1301 ZMUX4_0/Z1_0 BNE_4bit_0/x5/a_113_47# 0
C1302 NLC_4bit_3/a ZMUX4_0/sky130_fd_sc_hd__mux4_1_0/a_193_47# 0
C1303 ZMUX4_0/sky130_fd_sc_hd__mux4_1_1/a_750_97# ZMUX4_0/Z0_0 0.01525f
C1304 NLC_4bit_0/x1/a_281_297# A0 0
C1305 NLC_4bit_1/a NLC_4bit_2/x4/Y 0.00152f
C1306 ZMUX4_0/Zo_1 ZMUX4_0/sky130_fd_sc_hd__mux4_1_0/a_923_363# 0
C1307 ZMUX4_0/sky130_fd_sc_hd__mux4_1_1/a_193_413# BNE_4bit_0/x8/B 0
C1308 ZMUX4_0/Z0_1 Y0 0.00135f
C1309 NLC_4bit_1/a NLC_4bit_3/x1/a_281_297# 0
C1310 A1 A10 0
C1311 ZMUX4_0/y0 ZMUX4_0/Z0_1 0.38963f
C1312 ZMUX4_0/sky130_fd_sc_hd__mux4_1_0/a_1478_413# ZMUX4_0/y0 -0
C1313 NLC_4bit_3/x4/Y NLC_4bit_2/x4/Y 0.00517f
C1314 A3 NLC_4bit_1/x4/Y 0.00431f
C1315 NLC_4bit_1/a NLC_4bit_0/x2/a_109_297# 0
C1316 ZMUX4_0/Z3_0 ZMUX4_0/sky130_fd_sc_hd__mux4_1_0/a_668_97# 0.00125f
C1317 A15 A8 0
C1318 Y1 GND -0.02247f
C1319 sky130_fd_sc_hd__inv_1_3/A GND 0.05871f
C1320 NLC_4bit_3/x4/Y GND -0.19686f
C1321 A14 GND -0.1643f
C1322 ZMUX4_0/Z3_0 GND -0.13849f
C1323 A13 GND -0.29417f
C1324 A15 GND -0.49646f
C1325 NLC_4bit_3/x3/a_199_47# GND 0
C1326 ZMUX4_0/Z3_1 GND -0.27233f
C1327 A12 GND -0.13143f
C1328 Y2 GND 0.06785f
C1329 sky130_fd_sc_hd__inv_1_2/A GND 0.08583f
C1330 NLC_4bit_2/x4/Y GND -0.19685f
C1331 A10 GND -0.1939f
C1332 A9 GND -0.31905f
C1333 A11 GND -0.53842f
C1334 NLC_4bit_2/x3/a_199_47# GND 0
C1335 NLC_4bit_2/x3/a_113_297# GND 0
C1336 ZMUX4_0/Z2_1 GND -0.06345f
C1337 A8 GND -0.36081f
C1338 Y3 GND 1.12098f
C1339 sky130_fd_sc_hd__inv_1_0/A GND 0.06336f
C1340 NLC_4bit_1/x4/Y GND -0.19606f
C1341 A6 GND -0.1931f
C1342 ZMUX4_0/Z1_0 GND 0.26361f
C1343 A5 GND -0.31532f
C1344 A7 GND -0.55929f
C1345 NLC_4bit_1/x3/a_199_47# GND 0
C1346 NLC_4bit_1/x3/a_113_297# GND 0
C1347 ZMUX4_0/Z1_1 GND 0.20784f
C1348 A4 GND -0.36028f
C1349 NLC_4bit_0/x4/Y GND -0.19543f
C1350 A2 GND -0.18833f
C1351 ZMUX4_0/Z0_0 GND 0.13272f
C1352 A1 GND -0.31321f
C1353 A3 GND -0.55222f
C1354 NLC_4bit_0/x3/a_199_47# GND 0
C1355 NLC_4bit_0/x3/a_113_297# GND 0
C1356 ZMUX4_0/Z0_1 GND 0.09325f
C1357 A0 GND -0.35304f
C1358 sky130_fd_sc_hd__nand2_1_3/a_113_47# GND -0
C1359 sky130_fd_sc_hd__nand2_1_2/a_113_47# GND 0
C1360 sky130_fd_sc_hd__nand2_1_1/a_113_47# GND 0
C1361 sky130_fd_sc_hd__inv_1_1/Y GND 0.28408f
C1362 sky130_fd_sc_hd__nand2_1_0/a_113_47# GND 0
C1363 Y4 GND 0.17742f
C1364 VDD GND -15.92048f
C1365 BNE_4bit_0/x8/A GND -0.21556f
C1366 BNE_4bit_0/x8/a_27_297# GND 0
C1367 NLC_4bit_0/a GND -0.2209f
C1368 NLC_4bit_1/a GND 0.21482f
C1369 ZMUX4_0/y1 GND -0.23265f
C1370 BNE_4bit_0/x8/B GND -0.28263f
C1371 NLC_4bit_2/a GND -0.3747f
C1372 NLC_4bit_3/a GND -0.10876f
C1373 BNE_4bit_0/x2/Y GND -0.33403f
C1374 BNE_4bit_0/x3/Y GND -0.1359f
C1375 BNE_4bit_0/x3/A GND -0.23075f
C1376 ZMUX4_0/Zo_0 GND 0.03104f
C1377 ZMUX4_0/y0 GND -0.73365f
C1378 ZMUX4_0/Z2_0 GND -0.16921f
C1379 ZMUX4_0/sky130_fd_sc_hd__mux4_1_1/a_834_97# GND 0
C1380 ZMUX4_0/sky130_fd_sc_hd__mux4_1_1/a_668_97# GND 0
C1381 ZMUX4_0/sky130_fd_sc_hd__mux4_1_1/a_193_47# GND -0
C1382 ZMUX4_0/sky130_fd_sc_hd__mux4_1_1/a_27_47# GND 0.01709f
C1383 ZMUX4_0/sky130_fd_sc_hd__mux4_1_1/a_1478_413# GND 0.00815f
C1384 ZMUX4_0/sky130_fd_sc_hd__mux4_1_1/a_1290_413# GND 0.00418f
C1385 ZMUX4_0/sky130_fd_sc_hd__mux4_1_1/a_750_97# GND 0.00467f
C1386 ZMUX4_0/sky130_fd_sc_hd__mux4_1_1/a_757_363# GND 0
C1387 ZMUX4_0/sky130_fd_sc_hd__mux4_1_1/a_277_47# GND 0.00476f
C1388 ZMUX4_0/sky130_fd_sc_hd__mux4_1_1/a_247_21# GND 0
C1389 ZMUX4_0/sky130_fd_sc_hd__mux4_1_1/a_193_413# GND -0
C1390 ZMUX4_0/sky130_fd_sc_hd__mux4_1_1/a_27_413# GND -0
C1391 ZMUX4_0/Zo_1 GND 0.0795f
C1392 ZMUX4_0/sky130_fd_sc_hd__mux4_1_0/a_193_47# GND -0
C1393 ZMUX4_0/sky130_fd_sc_hd__mux4_1_0/a_27_47# GND 0.0209f
C1394 ZMUX4_0/sky130_fd_sc_hd__mux4_1_0/a_1478_413# GND 0.00783f
C1395 ZMUX4_0/sky130_fd_sc_hd__mux4_1_0/a_1290_413# GND -0
C1396 ZMUX4_0/sky130_fd_sc_hd__mux4_1_0/a_750_97# GND -0
C1397 ZMUX4_0/sky130_fd_sc_hd__mux4_1_0/a_277_47# GND 0
C1398 ZMUX4_0/sky130_fd_sc_hd__mux4_1_0/a_247_21# GND -0
C1399 ZMUX4_0/sky130_fd_sc_hd__mux4_1_0/a_193_413# GND -0
C1400 ZMUX4_0/sky130_fd_sc_hd__mux4_1_0/a_27_413# GND -0
C1401 Y0 GND -0.032f
C1402 sky130_fd_sc_hd__inv_1_4/A GND 0.09574f
.ends
