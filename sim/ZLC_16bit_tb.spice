* =============================================================
* Testbench: ZLC_16bit Critical Path Measurement (A7 -> Y1)
* Process  : SkyWater SKY130 (sky130_fd_sc_hd)
* Stimulus : Toggle A[7] while A[15:8] = 0 and A[6:0] = 0
* Measure  : Propagation delay to Y[1] 50% voltage level
* =============================================================

* ---- Include PDK libs ----------------------------------------
.lib $PDK_ROOT/$PDK/libs.tech/combined/sky130.lib.spice tt

* ---- Include DUT ----------------------------------------
.include "../magic/ZLC_16bit.spice"

* ---- Global supply ------------------------------------------
V_supply_vdd VDD 0 DC 1.8

* ---- Stimulus: Đưa xung vào chân A7 ----
Va7 A7 0 PWL(
+ 0ns     0
+ 2ns     0
+ 2.05ns  1.8
+ 12ns    1.8
+ 12.05ns 0
+ 20ns    0
+ )

Va15 A15 0 DC 0
Va14 A14 0 DC 0
Va13 A13 0 DC 0
Va12 A12 0 DC 0
Va11 A11 0 DC 0
Va10 A10 0 DC 0
Va9  A9  0 DC 0
Va8  A8  0 DC 0
Va6  A6  0 DC 0
Va5  A5  0 DC 0
Va4  A4  0 DC 0
Va3  A3  0 DC 0
Va2  A2  0 DC 0
Va1  A1  0 DC 0
Va0  A0  0 DC 0

* ---- DUT instantiation (Đầy đủ 23 chân khớp chuẩn Layout) -----
X1 Y4 Y0 Y2 Y3 A9 A8 A10 A11 A15 A14 A13 A12 A7 A6 A5 A4 A3 A2 A1 A0 0 Y1 VDD ZLC_16bit

* ---- Load capacitance -----------------------
Cload_y4  Y4   0  0.01pF
Cload_y3  Y3   0  0.01pF
Cload_y2  Y2   0  0.01pF
Cload_y1  Y1   0  0.01pF
Cload_y0  Y0   0  0.01pF

* ---- Analysis & Measurements ---
.save v(A7) v(Y4) v(Y3) v(Y2) v(Y1) v(Y0)
.control
  tran 10ps 20ns
  write ZLC_16bit.rcx.raw all

  meas tran tpd_y1_fall trig v(A7) val=0.9 rise=1 targ v(Y1) val=0.9 fall=1

  meas tran tpd_y1_rise trig v(A7) val=0.9 fall=1 targ v(Y1) val=0.9 rise=1

  print tpd_y1_fall tpd_y1_rise
.endc

.end
