.include /usr/local/share/pdk//sky130B/libs.ref/sky130_fd_sc_hd/spice/sky130_fd_sc_hd.spice
.include /home/bob/projects/team/xschem/ZLC_16bit.spice
